;; ============================================================================
;; Cadence Virtuoso SKILL Schematic Generator: PWM_CTRL
;; Generated by AMS Digital Optimizer (Multi-Level DAG Engine)
;; ============================================================================

procedure( create_PWM_CTRL_schematic(libName cellName)
  let((cvId instId x y yStep)
    cvId = dbOpenCellViewByType(libName cellName "schematic" "schematic" "w")
    if( null(cvId) then
      error("Failed to open schematic cellview for write: %s/%s" libName cellName)
    )

    yStep = 1.5

    ;; --- Column 0: Sequential Register Bank (DFFR) ---
    x = 0.0
    y = 0.0
    instId = dbCreateInstByMasterName(cvId "tsmcN65" "DFFR" "symbol" "cnt_0_dff" list(x y) "R0")
    y = y + yStep
    instId = dbCreateInstByMasterName(cvId "tsmcN65" "DFFR" "symbol" "cnt_1_dff" list(x y) "R0")
    y = y + yStep
    instId = dbCreateInstByMasterName(cvId "tsmcN65" "DFFR" "symbol" "cnt_2_dff" list(x y) "R0")
    y = y + yStep
    instId = dbCreateInstByMasterName(cvId "tsmcN65" "DFFR" "symbol" "cnt_3_dff" list(x y) "R0")
    y = y + yStep

    ;; --- Column 1: Multi-Level Combinational Gates ---
    x = 3.0
    y = 0.0
    ;; Node: cnt[0] = cnt[0]
    y = y + yStep
    ;; Node: cnt[0]_d = INV(cnt[0])
    y = y + yStep
    ;; Node: cnt[1] = cnt[1]
    y = y + yStep
    ;; Node: cnt[1]_d = XOR2(cnt[0], cnt[1])
    y = y + yStep
    ;; Node: cnt[2] = cnt[2]
    y = y + yStep
    ;; Node: cnt[2]_d = MUX2(cnt[0], cnt[2], XOR2(cnt[1], cnt[2]))
    y = y + yStep
    ;; Node: cnt[3] = cnt[3]
    y = y + yStep
    ;; Node: cnt[3]_d = MUX2(cnt[3], AND3(cnt[0], cnt[1], cnt[2]), NAND3(cnt[0], cnt[1], cnt[2]))
    y = y + yStep
    ;; Node: eff_oc_mode[0] = c_DfT_oc_dig_VDD[0]
    y = y + yStep
    ;; Node: eff_oc_mode[1] = c_DfT_oc_dig_VDD[1]
    y = y + yStep
    ;; Node: is_az_mode = NOR2(eff_oc_mode[1], eff_oc_mode[0])
    y = y + yStep
    ;; Node: is_chop_mode = AND2(eff_oc_mode[1], INV(eff_oc_mode[0]))
    y = y + yStep
    ;; Node: is_pwm_active_window = OR2(OR2(OR2(AND2(INV(cnt[2]), cnt[3]), AND2(cnt[2], INV(cnt[3]))), AND2(cnt[1], INV(cnt[3]))), AND3(INV(cnt[0]), INV(cnt[1]), cnt[3]))
    y = y + yStep
    ;; Node: is_pwm_sample_window = MUX2(cnt[0], AND3(cnt[1], cnt[2], cnt[3]), MUX2(cnt[1], AND2(cnt[2], cnt[3]), AND2(cnt[2], cnt[3])))
    y = y + yStep
    ;; Node: en_LP = OR3(AND2(is_chop_mode, is_pwm_active_window), AND2(INV(is_chop_mode), en_LP_ext), is_az_mode)
    y = y + yStep
    ;; Node: en_LowFreq = MUX2(is_az_mode, OR2(INV(is_chop_mode), is_pwm_sample_window), 0.0)
    y = y + yStep
    ;; Node: oc_select = OR3(AND2(is_chop_mode, is_pwm_active_window), AND2(INV(is_chop_mode), oc_select_ext), is_az_mode)
    y = y + yStep
    ;; Node: oc_ctrl_bgr = MUX2(is_az_mode, OR2(INV(is_chop_mode), is_pwm_sample_window), 0.0)
    y = y + yStep
    ;; Node: oc_ctrl_cp = OR3(AND2(is_chop_mode, is_pwm_active_window), AND2(INV(is_chop_mode), oc_ctrl_cp_ext), is_az_mode)
    y = y + yStep

    ;; Save and Check
    schCheck(cvId)
    dbSave(cvId)
    dbClose(cvId)
    printf("[OK] Generated Virtuoso schematic for %s\n" cellName)
  )
)

;; Load and execute:
;; create_PWM_CTRL_schematic("my_ams_lib" "PWM_CTRL")
