`include "constants.vams"
`include "disciplines.vams"

// ============================================================================
// Module: PWM_CTRL
// Generated by Unified Espresso-MV Silicon Optimizer
// Cadence Spectre & Virtuoso Compatible Verilog-A Model
//
// Silicon Area & Gate Complexity:
//   - Total Standard Cells     : 74 cells
//   - Inverter Equivalents (GE): 318.0 GE (1 GE = 1 Inverter = 2 Transistors)
//   - Est. Transistor Count    : 636 transistors
//
// Architecture:
//   - Multi-output shared intermediate nodes (w_c*) evaluated once
//   - Native CMOS DeMorgan inverting NAND-NAND topology
//
// Standard Cell Bill of Materials:
//   - NAND4   :  24 cells ( 96.0 GE,  192 transistors)
//   - NAND2   :  18 cells ( 36.0 GE,   72 transistors)
//   - NAND3   :  11 cells ( 33.0 GE,   66 transistors)
//   - INV     :  10 cells ( 10.0 GE,   20 transistors)
//   - DFFR    :   7 cells (119.0 GE,  238 transistors)
//   - MUX2    :   4 cells ( 24.0 GE,   48 transistors)
// ============================================================================

module PWM_CTRL (VDD, VSS, sub, res_n, c_DfT_en_LP, c_DfT_en_PWM, c_DfT_oc_dig_VDD, en_LP, oc_select, oc_ctrl_cp, oc_ctrl_bgr, clk_i, en_lowFreq, oc_select_ext, oc_ctrl_cp_ext, en_LP_ext, c_metalFix_invert_oc_defaults);
  input VDD; electrical VDD;
  input VSS; electrical VSS;
  input sub; electrical sub;
  input res_n; electrical res_n;
  input c_DfT_en_LP; electrical c_DfT_en_LP;
  input c_DfT_en_PWM; electrical c_DfT_en_PWM;
  input [1:0] c_DfT_oc_dig_VDD; electrical [1:0] c_DfT_oc_dig_VDD;
  output en_LP; electrical en_LP;
  output oc_select; electrical oc_select;
  output oc_ctrl_cp; electrical oc_ctrl_cp;
  output oc_ctrl_bgr; electrical oc_ctrl_bgr;
  input clk_i; electrical clk_i;
  output en_lowFreq; electrical en_lowFreq;
  output oc_select_ext; electrical oc_select_ext;
  output oc_ctrl_cp_ext; electrical oc_ctrl_cp_ext;
  output en_LP_ext; electrical en_LP_ext;
  input c_metalFix_invert_oc_defaults; electrical c_metalFix_invert_oc_defaults;

  parameter real vth   = 0.900;
  parameter real tdel  = 30p;
  parameter real trise = 30p;
  parameter real tfall = 30p;

  analog function real INV;
    input a; real a;
    INV = !(a > 0.5) ? 1.0 : 0.0;
  endfunction

  analog function real NAND2;
    input a, b; real a, b;
    NAND2 = !((a > 0.5) && (b > 0.5)) ? 1.0 : 0.0;
  endfunction

  analog function real NAND3;
    input a, b, c; real a, b, c;
    NAND3 = !((a > 0.5) && (b > 0.5) && (c > 0.5)) ? 1.0 : 0.0;
  endfunction

  analog function real NAND4;
    input a, b, c, d; real a, b, c, d;
    NAND4 = !((a > 0.5) && (b > 0.5) && (c > 0.5) && (d > 0.5)) ? 1.0 : 0.0;
  endfunction

  analog function real MUX2;
    input s, d0, d1; real s, d0, d1;
    MUX2 = (s > 0.5) ? d1 : d0;
  endfunction

  // Internal State Registers
  real cnt_3_q, cnt_3_d;
  real cnt_2_q, cnt_2_d;
  real cnt_1_q, cnt_1_d;
  real cnt_0_q, cnt_0_d;
  real startup_q, startup_d;
  real en_LP_q, en_LP_d;
  real oc_ctrl_bgr_q, oc_ctrl_bgr_d;

  // Primary Input Logic Variables
  real c_DfT_en_LP_in;
  real c_DfT_en_PWM_in;
  real c_DfT_oc_dig_VDD_1_in;
  real c_DfT_oc_dig_VDD_0_in;
  real c_metalFix_invert_oc_defaults_in;

  // Input Polarity Inversion Pool Wires
  real w_inv_c_DfT_en_LP_in, w_inv_c_DfT_en_PWM_in, w_inv_c_DfT_oc_dig_VDD_1_in, w_inv_c_DfT_oc_dig_VDD_0_in, w_inv_c_metalFix_invert_oc_defaults_in, w_inv_cnt_3_q, w_inv_cnt_2_q, w_inv_cnt_1_q, w_inv_cnt_0_q, w_inv_startup_q, w_inv_en_LP_q, w_inv_oc_ctrl_bgr_q;

  // Shared Intermediate Product Term Nodes (53 unique shared cubes)
  real w_c0, w_c1, w_c2, w_c3, w_c4, w_c5, w_c6, w_c7, w_c8, w_c9, w_c10, w_c11, w_c12, w_c13, w_c14, w_c15, w_c16, w_c17, w_c18, w_c19, w_c20, w_c21, w_c22, w_c23, w_c24, w_c25, w_c26, w_c27, w_c28, w_c29, w_c30, w_c31, w_c32, w_c33, w_c34, w_c35, w_c36, w_c37, w_c38, w_c39, w_c40, w_c41, w_c42, w_c43, w_c44, w_c45, w_c46, w_c47, w_c48, w_c49, w_c50, w_c51, w_c52;

  // Combinational Target Evaluation Wires
  real oc_select_val, oc_ctrl_cp_val, en_lowFreq_val;

  analog begin
    @(initial_step) begin
      cnt_3_q = 0.0;
      cnt_2_q = 0.0;
      cnt_1_q = 0.0;
      cnt_0_q = 0.0;
      startup_q = 1.0;
      en_LP_q = 0.0;
      oc_ctrl_bgr_q = 1.0;
    end

    // Asynchronous Reset: res_n falling edge
    @(cross(V(res_n) - vth, -1)) begin
      cnt_3_q = 0.0;
      cnt_2_q = 0.0;
      cnt_1_q = 0.0;
      cnt_0_q = 0.0;
      startup_q = 1.0;
      en_LP_q = 0.0;
      oc_ctrl_bgr_q = 1.0;
    end

    // Clock Edge Register Capture
    @(cross(V(clk_i) - vth, +1)) begin
      if (V(res_n) > vth) begin
        cnt_3_q = (cnt_3_d > 0.5) ? 1.0 : 0.0;
        cnt_2_q = (cnt_2_d > 0.5) ? 1.0 : 0.0;
        cnt_1_q = (cnt_1_d > 0.5) ? 1.0 : 0.0;
        cnt_0_q = (cnt_0_d > 0.5) ? 1.0 : 0.0;
        startup_q = (startup_d > 0.5) ? 1.0 : 0.0;
        en_LP_q = (en_LP_d > 0.5) ? 1.0 : 0.0;
        oc_ctrl_bgr_q = (oc_ctrl_bgr_d > 0.5) ? 1.0 : 0.0;
      end
    end

    // Primary Input Level Conversions
    c_DfT_en_LP_in                   = (V(c_DfT_en_LP) > V(VDD,VSS)*0.5) ? 1.0 : 0.0;
    c_DfT_en_PWM_in                  = (V(c_DfT_en_PWM) > V(VDD,VSS)*0.5) ? 1.0 : 0.0;
    c_DfT_oc_dig_VDD_1_in            = (V(c_DfT_oc_dig_VDD[1]) > V(VDD,VSS)*0.5) ? 1.0 : 0.0;
    c_DfT_oc_dig_VDD_0_in            = (V(c_DfT_oc_dig_VDD[0]) > V(VDD,VSS)*0.5) ? 1.0 : 0.0;
    c_metalFix_invert_oc_defaults_in = (V(c_metalFix_invert_oc_defaults) > V(VDD,VSS)*0.5) ? 1.0 : 0.0;

    // -------------------------------------------------------------------------
    // 1. Global Input & Register Polarity Inversion Pool
    // -------------------------------------------------------------------------
    w_inv_c_DfT_en_LP_in                   = INV(c_DfT_en_LP_in);
    w_inv_c_DfT_en_PWM_in                  = INV(c_DfT_en_PWM_in);
    w_inv_c_DfT_oc_dig_VDD_1_in            = INV(c_DfT_oc_dig_VDD_1_in);
    w_inv_c_DfT_oc_dig_VDD_0_in            = INV(c_DfT_oc_dig_VDD_0_in);
    w_inv_c_metalFix_invert_oc_defaults_in = INV(c_metalFix_invert_oc_defaults_in);
    w_inv_cnt_3_q                          = INV(cnt_3_q);
    w_inv_cnt_2_q                          = INV(cnt_2_q);
    w_inv_cnt_1_q                          = INV(cnt_1_q);
    w_inv_cnt_0_q                          = INV(cnt_0_q);
    w_inv_startup_q                        = INV(startup_q);
    w_inv_en_LP_q                          = INV(en_LP_q);
    w_inv_oc_ctrl_bgr_q                    = INV(oc_ctrl_bgr_q);

    // -------------------------------------------------------------------------
    // 2. Shared Intermediate Product Terms (53 unique CMOS NAND gates)
    //    Terms shared across multiple outputs are evaluated ONCE and reused.
    // -------------------------------------------------------------------------
    w_c0  = NAND3(w_inv_c_DfT_en_LP_in, w_inv_c_DfT_oc_dig_VDD_1_in, w_inv_c_DfT_oc_dig_VDD_0_in);  // Output: oc_select
    w_c1  = NAND3(w_inv_c_DfT_en_LP_in, c_DfT_oc_dig_VDD_1_in, c_DfT_oc_dig_VDD_0_in);  // Output: oc_select
    w_c2  = NAND3(INV(NAND4(w_inv_c_DfT_en_LP_in, w_inv_c_DfT_en_PWM_in, w_inv_c_DfT_oc_dig_VDD_1_in, w_inv_c_DfT_oc_dig_VDD_0_in)), INV(NAND4(w_inv_c_metalFix_invert_oc_defaults_in, w_inv_cnt_3_q, w_inv_cnt_2_q, w_inv_cnt_1_q)), INV(NAND2(cnt_0_q, startup_q)));  // Output: oc_ctrl_cp
    w_c3  = NAND2(INV(NAND4(w_inv_c_DfT_en_LP_in, w_inv_c_DfT_oc_dig_VDD_1_in, w_inv_c_DfT_oc_dig_VDD_0_in, c_metalFix_invert_oc_defaults_in)), INV(INV(w_inv_oc_ctrl_bgr_q)));  // Output: oc_ctrl_cp
    w_c4  = NAND4(w_inv_c_DfT_en_LP_in, c_DfT_oc_dig_VDD_1_in, c_metalFix_invert_oc_defaults_in, oc_ctrl_bgr_q);  // Output: oc_ctrl_cp
    w_c5  = NAND2(INV(NAND4(w_inv_c_DfT_en_LP_in, c_DfT_oc_dig_VDD_1_in, c_DfT_oc_dig_VDD_0_in, w_inv_c_metalFix_invert_oc_defaults_in)), INV(INV(w_inv_oc_ctrl_bgr_q)));  // Output: oc_ctrl_cp
    w_c6  = NAND4(w_inv_c_DfT_en_LP_in, w_inv_c_DfT_oc_dig_VDD_0_in, w_inv_c_metalFix_invert_oc_defaults_in, oc_ctrl_bgr_q);  // Output: oc_ctrl_cp
    w_c7  = NAND4(w_inv_c_DfT_en_LP_in, w_inv_c_DfT_oc_dig_VDD_1_in, c_DfT_oc_dig_VDD_0_in, oc_ctrl_bgr_q);  // Output: oc_ctrl_cp
    w_c8  = NAND3(INV(NAND4(w_inv_c_DfT_en_LP_in, w_inv_c_DfT_en_PWM_in, c_DfT_oc_dig_VDD_1_in, c_DfT_oc_dig_VDD_0_in)), INV(NAND4(c_metalFix_invert_oc_defaults_in, w_inv_cnt_3_q, w_inv_cnt_2_q, w_inv_cnt_1_q)), INV(NAND2(cnt_0_q, startup_q)));  // Output: oc_ctrl_cp
    w_c9  = NAND2(INV(NAND4(w_inv_c_DfT_en_LP_in, w_inv_c_DfT_en_PWM_in, c_DfT_oc_dig_VDD_1_in, c_DfT_oc_dig_VDD_0_in)), INV(NAND3(c_metalFix_invert_oc_defaults_in, cnt_1_q, w_inv_cnt_0_q)));  // Shared: en_lowFreq, oc_ctrl_bgr_d
    w_c10 = NAND2(INV(NAND4(w_inv_c_DfT_en_LP_in, w_inv_c_DfT_en_PWM_in, c_DfT_oc_dig_VDD_1_in, c_DfT_oc_dig_VDD_0_in)), INV(NAND3(c_metalFix_invert_oc_defaults_in, w_inv_cnt_0_q, w_inv_startup_q)));  // Shared: en_lowFreq, oc_ctrl_bgr_d
    w_c11 = NAND2(INV(NAND4(w_inv_c_DfT_en_LP_in, w_inv_c_DfT_en_PWM_in, c_DfT_oc_dig_VDD_1_in, c_DfT_oc_dig_VDD_0_in)), INV(NAND3(c_metalFix_invert_oc_defaults_in, cnt_2_q, w_inv_cnt_0_q)));  // Shared: en_lowFreq, oc_ctrl_bgr_d
    w_c12 = NAND2(INV(NAND4(w_inv_c_DfT_en_LP_in, w_inv_c_DfT_en_PWM_in, w_inv_c_DfT_oc_dig_VDD_1_in, w_inv_c_DfT_oc_dig_VDD_0_in)), INV(NAND3(w_inv_c_metalFix_invert_oc_defaults_in, cnt_3_q, w_inv_cnt_0_q)));  // Shared: en_lowFreq, oc_ctrl_bgr_d
    w_c13 = NAND2(INV(NAND4(w_inv_c_DfT_en_LP_in, w_inv_c_DfT_en_PWM_in, c_DfT_oc_dig_VDD_1_in, c_DfT_oc_dig_VDD_0_in)), INV(NAND3(c_metalFix_invert_oc_defaults_in, cnt_3_q, w_inv_cnt_0_q)));  // Shared: en_lowFreq, oc_ctrl_bgr_d
    w_c14 = NAND2(INV(NAND4(w_inv_c_DfT_en_LP_in, w_inv_c_DfT_en_PWM_in, w_inv_c_DfT_oc_dig_VDD_1_in, w_inv_c_DfT_oc_dig_VDD_0_in)), INV(NAND3(w_inv_c_metalFix_invert_oc_defaults_in, w_inv_cnt_0_q, w_inv_startup_q)));  // Shared: en_lowFreq, oc_ctrl_bgr_d
    w_c15 = NAND3(w_inv_c_DfT_en_LP_in, c_DfT_en_PWM_in, en_LP_q);  // Output: en_lowFreq
    w_c16 = NAND2(INV(NAND4(w_inv_c_DfT_en_LP_in, w_inv_c_DfT_en_PWM_in, w_inv_c_DfT_oc_dig_VDD_1_in, w_inv_c_DfT_oc_dig_VDD_0_in)), INV(NAND3(w_inv_c_metalFix_invert_oc_defaults_in, cnt_2_q, w_inv_cnt_0_q)));  // Shared: en_lowFreq, oc_ctrl_bgr_d
    w_c17 = NAND2(INV(NAND4(w_inv_c_DfT_en_LP_in, w_inv_c_DfT_en_PWM_in, w_inv_c_DfT_oc_dig_VDD_1_in, w_inv_c_DfT_oc_dig_VDD_0_in)), INV(NAND3(w_inv_c_metalFix_invert_oc_defaults_in, cnt_1_q, w_inv_cnt_0_q)));  // Shared: en_lowFreq, oc_ctrl_bgr_d
    w_c18 = NAND4(w_inv_cnt_3_q, cnt_2_q, cnt_1_q, cnt_0_q);  // Output: cnt[3]_d
    w_c19 = NAND2(cnt_3_q, w_inv_cnt_0_q);  // Output: cnt[3]_d
    w_c20 = NAND2(cnt_3_q, w_inv_cnt_2_q);  // Output: cnt[3]_d
    w_c21 = NAND2(cnt_3_q, w_inv_cnt_1_q);  // Output: cnt[3]_d
    w_c22 = NAND2(cnt_2_q, w_inv_cnt_0_q);  // Output: cnt[2]_d
    w_c23 = NAND3(w_inv_cnt_2_q, cnt_1_q, cnt_0_q);  // Output: cnt[2]_d
    w_c24 = NAND2(cnt_2_q, w_inv_cnt_1_q);  // Output: cnt[2]_d
    w_c25 = NAND2(w_inv_cnt_1_q, cnt_0_q);  // Output: cnt[1]_d
    w_c26 = NAND2(cnt_1_q, w_inv_cnt_0_q);  // Output: cnt[1]_d
    w_c27 = cnt_0_q;  // Output: cnt[0]_d (direct literal)
    w_c28 = NAND2(w_inv_cnt_3_q, startup_q);  // Output: startup_d
    w_c29 = NAND2(w_inv_cnt_1_q, startup_q);  // Output: startup_d
    w_c30 = NAND2(w_inv_cnt_2_q, startup_q);  // Output: startup_d
    w_c31 = NAND2(w_inv_cnt_0_q, startup_q);  // Output: startup_d
    w_c32 = w_inv_c_DfT_en_LP_in;  // Output: en_LP_d (inverted literal)
    w_c33 = NAND3(c_DfT_en_PWM_in, w_inv_cnt_3_q, cnt_1_q);  // Output: en_LP_d
    w_c34 = NAND3(c_DfT_en_PWM_in, w_inv_cnt_1_q, cnt_0_q);  // Output: en_LP_d
    w_c35 = NAND3(c_DfT_en_PWM_in, cnt_2_q, w_inv_cnt_0_q);  // Output: en_LP_d
    w_c36 = NAND3(c_DfT_en_PWM_in, cnt_3_q, w_inv_cnt_2_q);  // Output: en_LP_d
    w_c37 = NAND2(INV(NAND4(w_inv_c_DfT_en_LP_in, c_DfT_en_PWM_in, w_inv_c_DfT_oc_dig_VDD_0_in, c_metalFix_invert_oc_defaults_in)), INV(NAND2(cnt_1_q, oc_ctrl_bgr_q)));  // Output: oc_ctrl_bgr_d
    w_c38 = NAND2(INV(NAND4(w_inv_c_DfT_en_LP_in, c_DfT_oc_dig_VDD_0_in, w_inv_c_metalFix_invert_oc_defaults_in, w_inv_cnt_3_q)), INV(NAND4(w_inv_cnt_2_q, w_inv_cnt_1_q, w_inv_cnt_0_q, w_inv_oc_ctrl_bgr_q)));  // Output: oc_ctrl_bgr_d
    w_c39 = NAND2(INV(NAND4(w_inv_c_DfT_en_LP_in, c_DfT_en_PWM_in, c_DfT_oc_dig_VDD_0_in, w_inv_c_metalFix_invert_oc_defaults_in)), INV(NAND2(cnt_3_q, oc_ctrl_bgr_q)));  // Output: oc_ctrl_bgr_d
    w_c40 = NAND2(INV(NAND4(w_inv_c_DfT_en_LP_in, c_DfT_en_PWM_in, c_DfT_oc_dig_VDD_1_in, c_metalFix_invert_oc_defaults_in)), INV(NAND3(cnt_3_q, cnt_2_q, cnt_1_q)));  // Output: oc_ctrl_bgr_d
    w_c41 = NAND2(INV(NAND4(w_inv_c_DfT_en_LP_in, c_DfT_en_PWM_in, w_inv_c_DfT_oc_dig_VDD_0_in, c_metalFix_invert_oc_defaults_in)), INV(NAND2(cnt_0_q, oc_ctrl_bgr_q)));  // Output: oc_ctrl_bgr_d
    w_c42 = NAND2(INV(NAND4(w_inv_c_DfT_en_LP_in, c_DfT_en_PWM_in, w_inv_c_DfT_oc_dig_VDD_0_in, c_metalFix_invert_oc_defaults_in)), INV(NAND2(cnt_3_q, oc_ctrl_bgr_q)));  // Output: oc_ctrl_bgr_d
    w_c43 = NAND2(INV(NAND4(w_inv_c_DfT_en_LP_in, c_DfT_en_PWM_in, w_inv_c_DfT_oc_dig_VDD_1_in, w_inv_c_metalFix_invert_oc_defaults_in)), INV(NAND3(cnt_3_q, cnt_2_q, cnt_1_q)));  // Output: oc_ctrl_bgr_d
    w_c44 = NAND2(INV(NAND4(w_inv_c_DfT_en_LP_in, w_inv_c_DfT_oc_dig_VDD_0_in, c_metalFix_invert_oc_defaults_in, w_inv_cnt_3_q)), INV(NAND4(w_inv_cnt_2_q, w_inv_cnt_1_q, w_inv_cnt_0_q, w_inv_oc_ctrl_bgr_q)));  // Output: oc_ctrl_bgr_d
    w_c45 = NAND4(w_inv_c_DfT_en_LP_in, c_DfT_oc_dig_VDD_1_in, w_inv_c_DfT_oc_dig_VDD_0_in, c_metalFix_invert_oc_defaults_in);  // Output: oc_ctrl_bgr_d
    w_c46 = NAND2(INV(NAND4(w_inv_c_DfT_en_LP_in, c_DfT_en_PWM_in, c_DfT_oc_dig_VDD_0_in, w_inv_c_metalFix_invert_oc_defaults_in)), INV(NAND2(cnt_2_q, oc_ctrl_bgr_q)));  // Output: oc_ctrl_bgr_d
    w_c47 = NAND4(w_inv_c_DfT_en_LP_in, w_inv_c_DfT_oc_dig_VDD_1_in, c_DfT_oc_dig_VDD_0_in, w_inv_c_metalFix_invert_oc_defaults_in);  // Output: oc_ctrl_bgr_d
    w_c48 = NAND2(INV(NAND4(w_inv_c_DfT_en_LP_in, c_DfT_en_PWM_in, c_DfT_oc_dig_VDD_0_in, w_inv_c_metalFix_invert_oc_defaults_in)), INV(NAND2(cnt_1_q, oc_ctrl_bgr_q)));  // Output: oc_ctrl_bgr_d
    w_c49 = NAND2(INV(NAND4(w_inv_c_DfT_en_LP_in, w_inv_c_DfT_en_PWM_in, c_DfT_oc_dig_VDD_0_in, w_inv_c_metalFix_invert_oc_defaults_in)), INV(INV(w_inv_oc_ctrl_bgr_q)));  // Output: oc_ctrl_bgr_d
    w_c50 = NAND2(INV(NAND4(w_inv_c_DfT_en_LP_in, w_inv_c_DfT_en_PWM_in, w_inv_c_DfT_oc_dig_VDD_0_in, c_metalFix_invert_oc_defaults_in)), INV(INV(w_inv_oc_ctrl_bgr_q)));  // Output: oc_ctrl_bgr_d
    w_c51 = NAND2(INV(NAND4(w_inv_c_DfT_en_LP_in, c_DfT_en_PWM_in, c_DfT_oc_dig_VDD_0_in, w_inv_c_metalFix_invert_oc_defaults_in)), INV(NAND2(cnt_0_q, oc_ctrl_bgr_q)));  // Output: oc_ctrl_bgr_d
    w_c52 = NAND2(INV(NAND4(w_inv_c_DfT_en_LP_in, c_DfT_en_PWM_in, w_inv_c_DfT_oc_dig_VDD_0_in, c_metalFix_invert_oc_defaults_in)), INV(NAND2(cnt_2_q, oc_ctrl_bgr_q)));  // Output: oc_ctrl_bgr_d

    // -------------------------------------------------------------------------
    // 3. Output Stage Combinational Logic (DeMorgan NAND Trees of Shared Nodes)
    // -------------------------------------------------------------------------
    oc_select_val   = NAND2(w_c0, w_c1);
    oc_ctrl_cp_val  = NAND2(INV(NAND4(w_c2, w_c3, w_c4, w_c5)), INV(NAND3(w_c6, w_c7, w_c8)));
    en_lowFreq_val  = NAND3(INV(NAND4(w_c9, w_c10, w_c11, w_c12)), INV(NAND4(w_c13, w_c14, w_c15, w_c16)), INV(INV(w_c17)));
    cnt_3_d         = NAND4(w_c18, w_c19, w_c20, w_c21);
    cnt_2_d         = NAND3(w_c22, w_c23, w_c24);
    cnt_1_d         = NAND2(w_c25, w_c26);
    cnt_0_d         = INV(w_c27);
    startup_d       = NAND4(w_c28, w_c29, w_c30, w_c31);
    en_LP_d         = NAND2(INV(NAND4(w_c32, w_c33, w_c34, w_c35)), INV(INV(w_c36)));
    oc_ctrl_bgr_d   = NAND2(INV(NAND4(INV(NAND4(w_c37, w_c17, w_c38, w_c39)), INV(NAND4(w_c10, w_c40, w_c11, w_c41)), INV(NAND4(w_c12, w_c13, w_c14, w_c42)), INV(NAND4(w_c43, w_c44, w_c45, w_c46)))), INV(NAND2(INV(NAND4(w_c47, w_c48, w_c49, w_c50)), INV(NAND4(w_c16, w_c51, w_c9, w_c52)))));

    // Analog Electrical Output Drivers
    V(en_LP)           <+ transition((en_LP_q > 0.5) ? V(VDD) : V(VSS), tdel, trise, tfall);
    V(oc_select)       <+ transition((oc_select_val > 0.5) ? V(VDD) : V(VSS), tdel, trise, tfall);
    V(oc_ctrl_cp)      <+ transition((oc_ctrl_cp_val > 0.5) ? V(VDD) : V(VSS), tdel, trise, tfall);
    V(oc_ctrl_bgr)     <+ transition((oc_ctrl_bgr_q > 0.5) ? V(VDD) : V(VSS), tdel, trise, tfall);
    V(en_lowFreq)      <+ transition((en_lowFreq_val > 0.5) ? V(VDD) : V(VSS), tdel, trise, tfall);
    V(oc_select_ext)   <+ transition((oc_select_val > 0.5) ? V(VDD) : V(VSS), tdel, trise, tfall);
    V(oc_ctrl_cp_ext)  <+ transition((oc_ctrl_cp_val > 0.5) ? V(VDD) : V(VSS), tdel, trise, tfall);
    V(en_LP_ext)       <+ transition((en_LP_q > 0.5) ? V(VDD) : V(VSS), tdel, trise, tfall);
  end
endmodule
