`include "constants.vams"
`include "disciplines.vams"

// ============================================================================
// Module: bandgap_trim_fsm_va
// Generated by AMS Digital Optimizer (Multi-Level DAG Synthesis Engine)
// Cadence Spectre & Virtuoso Compatible Verilog-A Model
//
// Circuit Complexity & Silicon Area Notes:
//   - Total Gate Count         : 10 cells
//   - Inverter Equivalents (GE) : 50.0 inverters (1 GE = 1 Inverter = 2 Transistors)
//   - Est. Transistor Count    : ~100 transistors
//
// Standard Cell Breakdown (Gate Counts & Inverter Weights):
//   - DFFR    :   4 cells ( 32.0 inverters eq.,   64 transistors)
//   - INV     :   1 cells (  1.0 inverters eq.,    2 transistors)
//   - MUX2    :   2 cells (  6.0 inverters eq.,   12 transistors)
//   - OR2     :   1 cells (  3.0 inverters eq.,    6 transistors)
//   - XOR2    :   2 cells (  8.0 inverters eq.,   16 transistors)
// ============================================================================

module bandgap_trim_fsm_va (clk, rst_n, start_trim, comp_high, trim_code, trim_done);
  input clk;
  electrical clk;
  input rst_n;
  electrical rst_n;
  input start_trim;
  electrical start_trim;
  input comp_high;
  electrical comp_high;
  output [2:0] trim_code;
  electrical [2:0] trim_code;
  output trim_done;
  electrical trim_done;

  // Electrical Parameters
  parameter real vhigh = 1.800;
  parameter real vlow  = 0.000;
  parameter real vth   = 0.900;
  parameter real tdel  = 30p;
  parameter real trise = 30p;
  parameter real tfall = 30p;

  // Analog Standard Cell Helper Functions
  analog function real INV;
    input a; real a;
    INV = !(a > vth) ? 1.0 : 0.0;
  endfunction

  analog function real NAND2;
    input a, b; real a, b;
    NAND2 = !((a > vth) && (b > vth)) ? 1.0 : 0.0;
  endfunction

  analog function real AND2;
    input a, b; real a, b;
    AND2 = ((a > vth) && (b > vth)) ? 1.0 : 0.0;
  endfunction

  analog function real NOR2;
    input a, b; real a, b;
    NOR2 = !((a > vth) || (b > vth)) ? 1.0 : 0.0;
  endfunction

  analog function real OR2;
    input a, b; real a, b;
    OR2 = ((a > vth) || (b > vth)) ? 1.0 : 0.0;
  endfunction

  analog function real XOR2;
    input a, b; real a, b;
    XOR2 = ((a > vth) != (b > vth)) ? 1.0 : 0.0;
  endfunction

  analog function real XNOR2;
    input a, b; real a, b;
    XNOR2 = ((a > vth) == (b > vth)) ? 1.0 : 0.0;
  endfunction

  analog function real MUX2;
    input s, d0, d1; real s, d0, d1;
    MUX2 = (s > vth) ? d1 : d0;
  endfunction

  analog function real AOI21;
    input a, b, c; real a, b, c;
    AOI21 = !(((a > vth) && (b > vth)) || (c > vth)) ? 1.0 : 0.0;
  endfunction

  analog function real OAI21;
    input a, b, c; real a, b, c;
    OAI21 = !(((a > vth) || (b > vth)) && (c > vth)) ? 1.0 : 0.0;
  endfunction

  analog function real NAND3;
    input a, b, c; real a, b, c;
    NAND3 = !((a > vth) && (b > vth) && (c > vth)) ? 1.0 : 0.0;
  endfunction

  analog function real AND3;
    input a, b, c; real a, b, c;
    AND3 = ((a > vth) && (b > vth) && (c > vth)) ? 1.0 : 0.0;
  endfunction

  analog function real NOR3;
    input a, b, c; real a, b, c;
    NOR3 = !((a > vth) || (b > vth) || (c > vth)) ? 1.0 : 0.0;
  endfunction

  analog function real OR3;
    input a, b, c; real a, b, c;
    OR3 = ((a > vth) || (b > vth) || (c > vth)) ? 1.0 : 0.0;
  endfunction

  analog function real NAND4;
    input a, b, c, d; real a, b, c, d;
    NAND4 = !((a > vth) && (b > vth) && (c > vth) && (d > vth)) ? 1.0 : 0.0;
  endfunction

  analog function real AND4;
    input a, b, c, d; real a, b, c, d;
    AND4 = ((a > vth) && (b > vth) && (c > vth) && (d > vth)) ? 1.0 : 0.0;
  endfunction

  // Internal State & Combinational Signals
  real trim_reg_0_q, trim_reg_0_d;
  real trim_reg_1_q, trim_reg_1_d;
  real trim_reg_2_q, trim_reg_2_d;
  real done_reg_q, done_reg_d;
  real trim_code_0_val;
  real trim_code_1_val;
  real trim_code_2_val;
  real trim_done_val;

  analog begin
    @(initial_step("static", "ac")) begin
      trim_reg_0_q = vlow;
      trim_reg_1_q = vlow;
      trim_reg_2_q = vlow;
      done_reg_q = vlow;
    end

    // Sequential Register Bank Clock Edge Sampling
    @(cross(V(clk) - vth, +1)) begin
      trim_reg_0_q = (trim_reg_0_d > vth) ? vhigh : vlow;
      trim_reg_1_q = (trim_reg_1_d > vth) ? vhigh : vlow;
      trim_reg_2_q = (trim_reg_2_d > vth) ? vhigh : vlow;
      done_reg_q = (done_reg_d > vth) ? vhigh : vlow;
    end

    // Multi-Level Combinational Logic Evaluations
    trim_reg_0_d = INV(trim_reg_0_q);
    trim_reg_1_d = XOR2(trim_reg_0_q, trim_reg_1_q);
    trim_reg_2_d = MUX2(trim_reg_0_q, trim_reg_2_q, XOR2(trim_reg_1_q, trim_reg_2_q));
    done_reg_d = MUX2(V(start_trim), done_reg_q, OR2(V(comp_high), done_reg_q));
    trim_code_0_val = trim_reg_0_q;
    trim_code_1_val = trim_reg_1_q;
    trim_code_2_val = trim_reg_2_q;
    trim_done_val = done_reg_q;

    // Analog Electrical Output Drivers
    V(trim_code[2]) <+ transition((trim_code_2_val > vth) ? vhigh : vlow, tdel, trise, tfall);
    V(trim_code[1]) <+ transition((trim_code_1_val > vth) ? vhigh : vlow, tdel, trise, tfall);
    V(trim_code[0]) <+ transition((trim_code_0_val > vth) ? vhigh : vlow, tdel, trise, tfall);
    V(trim_done) <+ transition((trim_done_val > vth) ? vhigh : vlow, tdel, trise, tfall);
  end
endmodule
