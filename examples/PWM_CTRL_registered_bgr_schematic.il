;; ============================================================================
;; Cadence Virtuoso SKILL Schematic Generator: PWM_CTRL
;; Generated by AMS Digital Optimizer (Multi-Level DAG Engine)
;; ============================================================================

procedure( create_PWM_CTRL_schematic(libName cellName)
  let((cvId instId x y yStep)
    cvId = dbOpenCellViewByType(libName cellName "schematic" "schematic" "w")
    if( null(cvId) then
      error("Failed to open schematic cellview for write: %s/%s" libName cellName)
    )

    yStep = 1.5

    ;; --- Column 0: Sequential Register Bank (DFFR) ---
    x = 0.0
    y = 0.0
    instId = dbCreateInstByMasterName(cvId "tsmcN65" "DFFR" "symbol" "oc_ctrl_bgr_dff" list(x y) "R0")
    y = y + yStep
    instId = dbCreateInstByMasterName(cvId "tsmcN65" "DFFR" "symbol" "cnt_0_dff" list(x y) "R0")
    y = y + yStep
    instId = dbCreateInstByMasterName(cvId "tsmcN65" "DFFR" "symbol" "cnt_1_dff" list(x y) "R0")
    y = y + yStep
    instId = dbCreateInstByMasterName(cvId "tsmcN65" "DFFR" "symbol" "cnt_2_dff" list(x y) "R0")
    y = y + yStep
    instId = dbCreateInstByMasterName(cvId "tsmcN65" "DFFR" "symbol" "cnt_3_dff" list(x y) "R0")
    y = y + yStep
    instId = dbCreateInstByMasterName(cvId "tsmcN65" "DFFR" "symbol" "startup_dff" list(x y) "R0")
    y = y + yStep

    ;; --- Column 1: Multi-Level Combinational Gates ---
    x = 3.0
    y = 0.0
    ;; Node: oc_ctrl_bgr = oc_ctrl_bgr
    y = y + yStep
    ;; Node: oc_ctrl_bgr_d = NOR2(c_DfT_en_LP, NAND2(NAND2(NAND2(NAND2(NAND2(NAND2(NAND2(NAND2(NAND2(INV(cnt[0]), NAND4(INV(cnt[1]), INV(cnt[2]), INV(cnt[3]), startup)), INV(c_metalFix_invert_oc_defaults)), NAND2(oc_ctrl_bgr, c_metalFix_invert_oc_defaults)), INV(c_DfT_oc_dig_VDD[1])), NAND2(c_metalFix_invert_oc_defaults, c_DfT_oc_dig_VDD[1])), INV(c_DfT_oc_dig_VDD[0])), NAND2(NAND2(NAND2(INV(c_metalFix_invert_oc_defaults), INV(c_DfT_oc_dig_VDD[1])), NAND2(NAND2(NAND2(oc_ctrl_bgr, INV(c_metalFix_invert_oc_defaults)), NAND2(NAND2(INV(cnt[0]), NAND4(INV(cnt[1]), INV(cnt[2]), INV(cnt[3]), startup)), c_metalFix_invert_oc_defaults)), c_DfT_oc_dig_VDD[1])), c_DfT_oc_dig_VDD[0])), INV(c_DfT_en_PWM)), NAND2(NAND2(NAND2(NAND2(NAND2(NAND2(NAND2(NAND3(cnt[1], cnt[2], cnt[3]), INV(c_metalFix_invert_oc_defaults)), NAND2(NAND2(NAND2(NAND4(cnt[0], cnt[3], cnt[1], cnt[2]), INV(oc_ctrl_bgr)), NAND2(INV(NAND4(cnt[0], cnt[1], cnt[2], cnt[3])), oc_ctrl_bgr)), c_metalFix_invert_oc_defaults)), INV(c_DfT_oc_dig_VDD[1])), NAND2(c_metalFix_invert_oc_defaults, c_DfT_oc_dig_VDD[1])), INV(c_DfT_oc_dig_VDD[0])), NAND2(NAND2(NAND2(INV(c_metalFix_invert_oc_defaults), INV(c_DfT_oc_dig_VDD[1])), NAND2(NAND2(NAND2(NAND2(NAND2(NAND4(cnt[0], cnt[3], cnt[1], cnt[2]), INV(oc_ctrl_bgr)), NAND2(INV(NAND4(cnt[0], cnt[1], cnt[2], cnt[3])), oc_ctrl_bgr)), INV(c_metalFix_invert_oc_defaults)), NAND2(NAND3(cnt[1], cnt[2], cnt[3]), c_metalFix_invert_oc_defaults)), c_DfT_oc_dig_VDD[1])), c_DfT_oc_dig_VDD[0])), c_DfT_en_PWM)))
    y = y + yStep
    ;; Node: cnt[0]_d = INV(cnt[0])
    y = y + yStep
    ;; Node: cnt[1]_d = AOI22(cnt[0], cnt[1], INV(cnt[0]), INV(cnt[1]))
    y = y + yStep
    ;; Node: cnt[2]_d = NAND2(NAND2(INV(NAND2(cnt[0], cnt[1])), INV(cnt[2])), NAND2(NAND2(cnt[0], cnt[1]), cnt[2]))
    y = y + yStep
    ;; Node: cnt[3]_d = NAND2(NAND2(INV(NAND3(cnt[0], cnt[1], cnt[2])), INV(cnt[3])), NAND2(NAND3(cnt[0], cnt[1], cnt[2]), cnt[3]))
    y = y + yStep
    ;; Node: startup_d = INV(NAND2(startup, NAND4(cnt[0], cnt[3], cnt[1], cnt[2])))
    y = y + yStep
    ;; Node: eff_oc_mode[0] = AOI22(c_DfT_oc_dig_VDD[0], c_metalFix_invert_oc_defaults, INV(c_DfT_oc_dig_VDD[0]), INV(c_metalFix_invert_oc_defaults))
    y = y + yStep
    ;; Node: eff_oc_mode[1] = AOI22(c_DfT_oc_dig_VDD[1], c_metalFix_invert_oc_defaults, INV(c_DfT_oc_dig_VDD[1]), INV(c_metalFix_invert_oc_defaults))
    y = y + yStep
    ;; Node: is_az_mode = NOR2(eff_oc_mode[0], eff_oc_mode[1])
    y = y + yStep
    ;; Node: is_static_0 = INV(NAND2(eff_oc_mode[0], INV(eff_oc_mode[1])))
    y = y + yStep
    ;; Node: is_static_1 = INV(NAND2(INV(eff_oc_mode[0]), eff_oc_mode[1]))
    y = y + yStep
    ;; Node: is_chop_mode = INV(NAND2(eff_oc_mode[0], eff_oc_mode[1]))
    y = y + yStep
    ;; Node: is_pwm_active_window = NOR3(cnt[1], cnt[2], cnt[3])
    y = y + yStep
    ;; Node: oc_select = INV(AOI22(INV(c_DfT_en_LP), is_chop_mode, INV(c_DfT_en_LP), is_az_mode))
    y = y + yStep
    ;; Node: oc_select_ext = oc_select
    y = y + yStep
    ;; Node: oc_ctrl_cp = NOR2(c_DfT_en_LP, NAND2(NAND2(NAND2(NAND2(AOI22(INV(is_chop_mode), oc_ctrl_bgr, is_chop_mode, INV(oc_ctrl_bgr)), INV(cnt[0])), NAND2(INV(NAND3(NAND2(is_chop_mode, INV(oc_ctrl_bgr)), NAND2(INV(is_chop_mode), oc_ctrl_bgr), NAND2(INV(NAND2(INV(NAND2(INV(NAND2(INV(NAND2(INV(cnt[1]), INV(cnt[2]))), INV(cnt[3]))), is_az_mode)), INV(oc_ctrl_bgr))), startup))), cnt[0])), INV(c_DfT_en_PWM)), NAND2(AOI22(INV(is_chop_mode), oc_ctrl_bgr, is_chop_mode, INV(oc_ctrl_bgr)), c_DfT_en_PWM)))
    y = y + yStep
    ;; Node: oc_ctrl_cp_ext = oc_ctrl_cp
    y = y + yStep
    ;; Node: en_LP = INV(AOI21(c_DfT_en_PWM, INV(is_pwm_active_window), c_DfT_en_LP))
    y = y + yStep
    ;; Node: en_LP_ext = en_LP
    y = y + yStep
    ;; Node: en_lowFreq = NOR2(c_DfT_en_LP, NAND2(NAND2(NAND4(is_az_mode, INV(is_chop_mode), NAND4(INV(cnt[1]), INV(cnt[2]), INV(cnt[3]), startup), INV(cnt[0])), INV(c_DfT_en_PWM)), NAND2(is_pwm_active_window, c_DfT_en_PWM)))
    y = y + yStep

    ;; Save and Check
    schCheck(cvId)
    dbSave(cvId)
    dbClose(cvId)
    printf("[OK] Generated Virtuoso schematic for %s\n" cellName)
  )
)

;; Load and execute:
;; create_PWM_CTRL_schematic("my_ams_lib" "PWM_CTRL")
