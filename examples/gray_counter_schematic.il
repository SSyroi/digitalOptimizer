;; ============================================================================
;; Cadence Virtuoso SKILL Schematic Generator: gray_counter
;; Generated by AMS Digital Optimizer (Multi-Level DAG Engine)
;; ============================================================================

procedure( create_gray_counter_schematic(libName cellName)
  let((cvId instId x y yStep)
    cvId = dbOpenCellViewByType(libName cellName "schematic" "schematic" "w")
    if( null(cvId) then
      error("Failed to open schematic cellview for write: %s/%s" libName cellName)
    )

    yStep = 1.5

    ;; --- Column 0: Sequential Register Bank (DFFR) ---
    x = 0.0
    y = 0.0
    instId = dbCreateInstByMasterName(cvId "tsmcN65" "DFFR" "symbol" "q_0_dff" list(x y) "R0")
    y = y + yStep
    instId = dbCreateInstByMasterName(cvId "tsmcN65" "DFFR" "symbol" "q_1_dff" list(x y) "R0")
    y = y + yStep
    instId = dbCreateInstByMasterName(cvId "tsmcN65" "DFFR" "symbol" "q_2_dff" list(x y) "R0")
    y = y + yStep

    ;; --- Column 1: Multi-Level Combinational Gates ---
    x = 3.0
    y = 0.0
    ;; Node: q[0]_d = XOR2(q[0], ena)
    y = y + yStep
    ;; Node: q[1]_d = MUX2(q[0], q[1], XOR2(q[1], ena))
    y = y + yStep
    ;; Node: q[2]_d = MUX2(q[2], AND3(q[0], q[1], ena), NAND3(q[0], q[1], ena))
    y = y + yStep
    ;; Node: count_bin[0] = q[0]
    y = y + yStep
    ;; Node: count_bin[1] = q[1]
    y = y + yStep
    ;; Node: count_bin[2] = q[2]
    y = y + yStep
    ;; Node: count_gray[2] = q[2]
    y = y + yStep
    ;; Node: count_gray[1] = XOR2(q[2], q[1])
    y = y + yStep
    ;; Node: count_gray[0] = XOR2(q[1], q[0])
    y = y + yStep

    ;; Save and Check
    schCheck(cvId)
    dbSave(cvId)
    dbClose(cvId)
    printf("[OK] Generated Virtuoso schematic for %s\n" cellName)
  )
)

;; Load and execute:
;; create_gray_counter_schematic("my_ams_lib" "gray_counter")
