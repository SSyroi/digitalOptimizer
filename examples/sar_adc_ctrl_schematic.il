;; ============================================================================
;; Cadence Virtuoso SKILL Schematic Generator: sar_adc_ctrl
;; Generated by AMS Digital Optimizer (Multi-Level DAG Engine)
;; ============================================================================

procedure( create_sar_adc_ctrl_schematic(libName cellName)
  let((cvId instId x y yStep)
    cvId = dbOpenCellViewByType(libName cellName "schematic" "schematic" "w")
    if( null(cvId) then
      error("Failed to open schematic cellview for write: %s/%s" libName cellName)
    )

    yStep = 1.5

    ;; --- Column 0: Sequential Register Bank (DFFR) ---
    x = 0.0
    y = 0.0
    instId = dbCreateInstByMasterName(cvId "tsmcN65" "DFFR" "symbol" "dac_reg_0_dff" list(x y) "R0")
    y = y + yStep
    instId = dbCreateInstByMasterName(cvId "tsmcN65" "DFFR" "symbol" "dac_reg_1_dff" list(x y) "R0")
    y = y + yStep
    instId = dbCreateInstByMasterName(cvId "tsmcN65" "DFFR" "symbol" "dac_reg_2_dff" list(x y) "R0")
    y = y + yStep
    instId = dbCreateInstByMasterName(cvId "tsmcN65" "DFFR" "symbol" "dac_reg_3_dff" list(x y) "R0")
    y = y + yStep
    instId = dbCreateInstByMasterName(cvId "tsmcN65" "DFFR" "symbol" "state_0_dff" list(x y) "R0")
    y = y + yStep
    instId = dbCreateInstByMasterName(cvId "tsmcN65" "DFFR" "symbol" "state_1_dff" list(x y) "R0")
    y = y + yStep
    instId = dbCreateInstByMasterName(cvId "tsmcN65" "DFFR" "symbol" "state_2_dff" list(x y) "R0")
    y = y + yStep
    instId = dbCreateInstByMasterName(cvId "tsmcN65" "DFFR" "symbol" "eoc_reg_dff" list(x y) "R0")
    y = y + yStep

    ;; --- Column 1: Multi-Level Combinational Gates ---
    x = 3.0
    y = 0.0
    ;; Node: dac_reg[0]_d = MUX2(dac_reg[0], MUX2(state[2], 0.0, NOR2(state[1], state[0])), OR3(state[2], state[1], state[0]))
    y = y + yStep
    ;; Node: dac_reg[1]_d = OR2(OR2(OR2(AND2(dac_reg[1], state[0]), AND3(INV(comp_out), dac_reg[1], state[2])), AND2(dac_reg[1], state[1])), AND3(INV(state[2]), state[1], state[0]))
    y = y + yStep
    ;; Node: dac_reg[2]_d = OR2(OR2(OR2(AND3(dac_reg[2], INV(state[1]), state[0]), AND3(INV(state[2]), state[1], INV(state[0]))), AND2(dac_reg[2], state[2])), AND3(INV(comp_out), dac_reg[2], state[0]))
    y = y + yStep
    ;; Node: dac_reg[3]_d = OR2(OR2(OR2(AND2(dac_reg[3], state[0]), AND3(INV(state[2]), INV(state[1]), state[0])), AND3(INV(comp_out), dac_reg[3], state[1])), AND2(dac_reg[3], state[2]))
    y = y + yStep
    ;; Node: state[0]_d = OR3(AND3(state[2], INV(state[1]), INV(state[0])), AND3(INV(state[2]), state[1], INV(state[0])), AND3(start, INV(state[1]), INV(state[0])))
    y = y + yStep
    ;; Node: state[1]_d = MUX2(state[2], XOR2(state[1], state[0]), 0.0)
    y = y + yStep
    ;; Node: state[2]_d = MUX2(state[2], AND2(state[1], state[0]), NOR2(state[1], state[0]))
    y = y + yStep
    ;; Node: eoc_reg_d = MUX2(state[2], 0.0, NOR2(state[1], state[0]))
    y = y + yStep
    ;; Node: dac_code[0] = dac_reg[0]
    y = y + yStep
    ;; Node: dac_code[1] = dac_reg[1]
    y = y + yStep
    ;; Node: dac_code[2] = dac_reg[2]
    y = y + yStep
    ;; Node: dac_code[3] = dac_reg[3]
    y = y + yStep
    ;; Node: eoc = eoc_reg
    y = y + yStep
    ;; Node: valid = eoc_reg
    y = y + yStep

    ;; Save and Check
    schCheck(cvId)
    dbSave(cvId)
    dbClose(cvId)
    printf("[OK] Generated Virtuoso schematic for %s\n" cellName)
  )
)

;; Load and execute:
;; create_sar_adc_ctrl_schematic("my_ams_lib" "sar_adc_ctrl")
