`include "constants.vams"
`include "disciplines.vams"

// ============================================================================
// Module: clock_divider_rst_va
// Generated by AMS Digital Optimizer (Multi-Level DAG Synthesis Engine)
// Cadence Spectre & Virtuoso Compatible Verilog-A Model
//
// Circuit Complexity & Silicon Area Notes:
//   - Total Gate Count         : 85 cells
//   - Inverter Equivalents (GE) : 231.0 inverters (1 GE = 1 Inverter = 2 Transistors)
//   - Est. Transistor Count    : ~462 transistors
//
// Standard Cell Breakdown (Gate Counts & Inverter Weights):
//   - AND2    :   9 cells ( 27.0 inverters eq.,   54 transistors)
//   - AND3    :  10 cells ( 40.0 inverters eq.,   80 transistors)
//   - AND4    :   4 cells ( 20.0 inverters eq.,   40 transistors)
//   - DFFR    :   5 cells ( 40.0 inverters eq.,   80 transistors)
//   - INV     :  34 cells ( 34.0 inverters eq.,   68 transistors)
//   - MUX2    :   5 cells ( 15.0 inverters eq.,   30 transistors)
//   - NOR3    :   1 cells (  3.0 inverters eq.,    6 transistors)
//   - OR2     :  16 cells ( 48.0 inverters eq.,   96 transistors)
//   - OR3     :   1 cells (  4.0 inverters eq.,    8 transistors)
// ============================================================================

module clock_divider_rst_va (clk, rst_n, load, div_ratio, clk_out, count);
  input clk;
  electrical clk;
  input rst_n;
  electrical rst_n;
  input load;
  electrical load;
  input [3:0] div_ratio;
  electrical [3:0] div_ratio;
  output clk_out;
  electrical clk_out;
  output [3:0] count;
  electrical [3:0] count;

  // Electrical Parameters
  parameter real vhigh = 1.800;
  parameter real vlow  = 0.000;
  parameter real vth   = 0.900;
  parameter real tdel  = 30p;
  parameter real trise = 30p;
  parameter real tfall = 30p;

  // Analog Standard Cell Helper Functions
  analog function real INV;
    input a; real a;
    INV = !(a > vth) ? 1.0 : 0.0;
  endfunction

  analog function real NAND2;
    input a, b; real a, b;
    NAND2 = !((a > vth) && (b > vth)) ? 1.0 : 0.0;
  endfunction

  analog function real AND2;
    input a, b; real a, b;
    AND2 = ((a > vth) && (b > vth)) ? 1.0 : 0.0;
  endfunction

  analog function real NOR2;
    input a, b; real a, b;
    NOR2 = !((a > vth) || (b > vth)) ? 1.0 : 0.0;
  endfunction

  analog function real OR2;
    input a, b; real a, b;
    OR2 = ((a > vth) || (b > vth)) ? 1.0 : 0.0;
  endfunction

  analog function real XOR2;
    input a, b; real a, b;
    XOR2 = ((a > vth) != (b > vth)) ? 1.0 : 0.0;
  endfunction

  analog function real XNOR2;
    input a, b; real a, b;
    XNOR2 = ((a > vth) == (b > vth)) ? 1.0 : 0.0;
  endfunction

  analog function real MUX2;
    input s, d0, d1; real s, d0, d1;
    MUX2 = (s > vth) ? d1 : d0;
  endfunction

  analog function real AOI21;
    input a, b, c; real a, b, c;
    AOI21 = !(((a > vth) && (b > vth)) || (c > vth)) ? 1.0 : 0.0;
  endfunction

  analog function real OAI21;
    input a, b, c; real a, b, c;
    OAI21 = !(((a > vth) || (b > vth)) && (c > vth)) ? 1.0 : 0.0;
  endfunction

  analog function real NAND3;
    input a, b, c; real a, b, c;
    NAND3 = !((a > vth) && (b > vth) && (c > vth)) ? 1.0 : 0.0;
  endfunction

  analog function real AND3;
    input a, b, c; real a, b, c;
    AND3 = ((a > vth) && (b > vth) && (c > vth)) ? 1.0 : 0.0;
  endfunction

  analog function real NOR3;
    input a, b, c; real a, b, c;
    NOR3 = !((a > vth) || (b > vth) || (c > vth)) ? 1.0 : 0.0;
  endfunction

  analog function real OR3;
    input a, b, c; real a, b, c;
    OR3 = ((a > vth) || (b > vth) || (c > vth)) ? 1.0 : 0.0;
  endfunction

  analog function real NAND4;
    input a, b, c, d; real a, b, c, d;
    NAND4 = !((a > vth) && (b > vth) && (c > vth) && (d > vth)) ? 1.0 : 0.0;
  endfunction

  analog function real AND4;
    input a, b, c, d; real a, b, c, d;
    AND4 = ((a > vth) && (b > vth) && (c > vth) && (d > vth)) ? 1.0 : 0.0;
  endfunction

  // Internal State & Combinational Signals
  real clk_out_q, clk_out_d;
  real cnt_reg_3_q, cnt_reg_3_d;
  real cnt_reg_2_q, cnt_reg_2_d;
  real cnt_reg_1_q, cnt_reg_1_d;
  real cnt_reg_0_q, cnt_reg_0_d;

  analog begin
    @(initial_step("static", "ac")) begin
      clk_out_q = vlow;
      cnt_reg_0_q = vlow;
      cnt_reg_1_q = vlow;
      cnt_reg_2_q = vlow;
      cnt_reg_3_q = vlow;
    end

    // Sequential Register Bank Clock Edge Sampling
    @(cross(V(clk) - vth, +1)) begin
      clk_out_q = (clk_out_d > vth) ? vhigh : vlow;
      cnt_reg_0_q = (cnt_reg_0_d > vth) ? vhigh : vlow;
      cnt_reg_1_q = (cnt_reg_1_d > vth) ? vhigh : vlow;
      cnt_reg_2_q = (cnt_reg_2_d > vth) ? vhigh : vlow;
      cnt_reg_3_q = (cnt_reg_3_d > vth) ? vhigh : vlow;
    end

    // Multi-Level Combinational Logic Evaluations
    clk_out = clk_out_q;
    clk_out_d = MUX2(clk_out_q, MUX2(V(load), MUX2(cnt_reg[3], NOR3(cnt_reg[2], cnt_reg[1], cnt_reg[0]), 0.0), 0.0), MUX2(V(load), MUX2(cnt_reg[3], OR3(cnt_reg[2], cnt_reg[1], cnt_reg[0]), 1.0), 0.0));
    cnt_reg_0_d = OR2(OR2(OR2(OR2(AND2(V(load), div_ratio[0]), AND3(INV(V(load)), cnt_reg[2], INV(cnt_reg[0]))), AND2(div_ratio[0], INV(cnt_reg[0]))), AND3(INV(V(load)), cnt_reg[3], INV(cnt_reg[0]))), AND3(INV(V(load)), cnt_reg[1], INV(cnt_reg[0])));
    cnt_reg_1_d = OR2(OR2(OR2(AND3(INV(V(load)), INV(cnt_reg[1]), cnt_reg[0]), AND2(V(load), div_ratio[1])), AND3(INV(V(load)), cnt_reg[1], INV(cnt_reg[0]))), AND4(div_ratio[1], INV(cnt_reg[3]), INV(cnt_reg[2]), INV(cnt_reg[0])));
    cnt_reg_2_d = OR2(OR2(OR2(OR2(AND2(V(load), div_ratio[2]), AND3(INV(V(load)), cnt_reg[2], INV(cnt_reg[1]))), AND4(INV(V(load)), INV(cnt_reg[2]), cnt_reg[1], cnt_reg[0])), AND3(INV(V(load)), cnt_reg[2], INV(cnt_reg[0]))), AND4(div_ratio[2], INV(cnt_reg[3]), INV(cnt_reg[1]), INV(cnt_reg[0])));
    cnt_reg_3_d = OR2(OR2(OR2(OR2(OR2(AND3(INV(V(load)), cnt_reg[3], INV(cnt_reg[2])), AND2(V(load), div_ratio[3])), AND3(INV(V(load)), cnt_reg[3], INV(cnt_reg[1]))), AND2(AND2(AND2(AND2(INV(V(load)), INV(cnt_reg[3])), cnt_reg[2]), cnt_reg[1]), cnt_reg[0])), AND3(INV(V(load)), cnt_reg[3], INV(cnt_reg[0]))), AND4(div_ratio[3], INV(cnt_reg[2]), INV(cnt_reg[1]), INV(cnt_reg[0])));
    count_0 = cnt_reg[0];
    count_1 = cnt_reg[1];
    count_2 = cnt_reg[2];
    count_3 = cnt_reg[3];

    // Analog Electrical Output Drivers
    V(clk_out) <+ transition((clk_out_q > vth) ? vhigh : vlow, tdel, trise, tfall);
    V(count[3]) <+ transition((count_3 > vth) ? vhigh : vlow, tdel, trise, tfall);
    V(count[2]) <+ transition((count_2 > vth) ? vhigh : vlow, tdel, trise, tfall);
    V(count[1]) <+ transition((count_1 > vth) ? vhigh : vlow, tdel, trise, tfall);
    V(count[0]) <+ transition((count_0 > vth) ? vhigh : vlow, tdel, trise, tfall);
  end
endmodule
