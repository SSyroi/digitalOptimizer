// =============================================================================
// Cadence Spectre Verilog-A Model for AMS Digital Block: clock_divider_rst
// Generated by Simulation-Driven Truth Table Synthesizer
// =============================================================================
`include "constants.vams"
`include "disciplines.vams"

module clock_divider_rst_va (clk, rst_n, load, div_ratio, clk_out, count);

  input clk;
  input rst_n;
  input load;
  input [3:0] div_ratio;
  output clk_out;
  output [3:0] count;

  electrical clk;
  electrical rst_n;
  electrical load;
  electrical [3:0] div_ratio;
  electrical clk_out;
  electrical [3:0] count;

  // ---------------------------------------------------------------------------
  // Technology & Timing Parameters (Cadence Spectre Compliant)
  // ---------------------------------------------------------------------------
  parameter real vdd   = 1.8;
  parameter real vth   = 0.9;
  parameter real tdel  = 10p; // Propagation delay
  parameter real trise = 10p; // Output rise time
  parameter real tfall = 10p; // Output fall time
  parameter real vtol  = 0;   // Voltage tolerance for cross event
  parameter real ttol  = 0;   // Time tolerance for cross event

  // ---------------------------------------------------------------------------
  // Custom Analog Standard Cell Gate Functions
  // ---------------------------------------------------------------------------
  analog function real INV;
    input a; real a;
    INV = (a > vth) ? 0.0 : 1.0;
  endfunction

  analog function real NAND2;
    input a, b; real a, b;
    NAND2 = !( (a > vth) && (b > vth) ) ? 1.0 : 0.0;
  endfunction

  analog function real NAND3;
    input a, b, c; real a, b, c;
    NAND3 = !( (a > vth) && (b > vth) && (c > vth) ) ? 1.0 : 0.0;
  endfunction

  analog function real NAND4;
    input a, b, c, d; real a, b, c, d;
    NAND4 = !( (a > vth) && (b > vth) && (c > vth) && (d > vth) ) ? 1.0 : 0.0;
  endfunction

  analog function real XOR2;
    input a, b; real a, b;
    XOR2 = ( (a > vth) ^ (b > vth) ) ? 1.0 : 0.0;
  endfunction

  // ---------------------------------------------------------------------------
  // Internal State & Combinational Variables
  // ---------------------------------------------------------------------------
  real clk_out_q;
  real clk_out_d;
  real cnt_reg_0_q;
  real cnt_reg_0_d;
  real cnt_reg_1_q;
  real cnt_reg_1_d;
  real cnt_reg_2_q;
  real cnt_reg_2_d;
  real cnt_reg_3_q;
  real cnt_reg_3_d;
  real clk_out_val;
  real count_0_val;
  real count_1_val;
  real count_2_val;
  real count_3_val;

  // ===========================================================================
  // Analog Behavioral Block
  // ===========================================================================
  analog begin
    // -------------------------------------------------------------------------
    // 1. Initial Step: DC Operating Point State Initialization
    // -------------------------------------------------------------------------
    @(initial_step("static", "ac")) begin
      clk_out_q = 0.0;
      cnt_reg_0_q = 0.0;
      cnt_reg_1_q = 0.0;
      cnt_reg_2_q = 0.0;
      cnt_reg_3_q = 0.0;
    end

    // -------------------------------------------------------------------------
    // 2. Sequential Clock Cross Event (Register Updates)
    // -------------------------------------------------------------------------
    @(cross(V(clk) - vth, 1, vtol, ttol)) begin
      if (V(rst_n) < vth) begin
        clk_out_q = 0.0;
        cnt_reg_0_q = 0.0;
        cnt_reg_1_q = 0.0;
        cnt_reg_2_q = 0.0;
        cnt_reg_3_q = 0.0;
      end else begin
        clk_out_q = clk_out_d;
        cnt_reg_0_q = cnt_reg_0_d;
        cnt_reg_1_q = cnt_reg_1_d;
        cnt_reg_2_q = cnt_reg_2_d;
        cnt_reg_3_q = cnt_reg_3_d;
      end
    end

    // -------------------------------------------------------------------------
    // 3. Combinational Logic Cones (Simplified & Tech-Mapped)
    // -------------------------------------------------------------------------
    // D-input for DFF clk_out:
    clk_out_d = 1.0;
    // D-input for DFF cnt_reg[0]:
    cnt_reg_0_d = INV(cnt_reg_0_q);
    // D-input for DFF cnt_reg[1]:
    cnt_reg_1_d = XOR2(cnt_reg_0_q, cnt_reg_1_q);
    // D-input for DFF cnt_reg[2]:
    cnt_reg_2_d = NAND3(NAND3(cnt_reg_0_q, cnt_reg_1_q, INV(cnt_reg_2_q)), NAND2(INV(cnt_reg_1_q), cnt_reg_2_q), NAND2(INV(cnt_reg_0_q), cnt_reg_2_q));
    // D-input for DFF cnt_reg[3]:
    cnt_reg_3_d = NAND4(NAND4(cnt_reg_0_q, cnt_reg_1_q, cnt_reg_2_q, INV(cnt_reg_3_q)), NAND2(INV(cnt_reg_2_q), cnt_reg_3_q), NAND2(INV(cnt_reg_0_q), cnt_reg_3_q), NAND2(INV(cnt_reg_1_q), cnt_reg_3_q));
    // Output clk_out:
    clk_out_val = 0.0;
    // Output count[0]:
    count_0_val = cnt_reg_0_q;
    // Output count[1]:
    count_1_val = cnt_reg_1_q;
    // Output count[2]:
    count_2_val = cnt_reg_2_q;
    // Output count[3]:
    count_3_val = cnt_reg_3_q;

    // -------------------------------------------------------------------------
    // 4. Analog Output Drivers (Continuous Transition Filters)
    // -------------------------------------------------------------------------
    V(clk_out) <+ transition(clk_out_val * vdd, tdel, trise, tfall);
    V(count[0]) <+ transition(count_0_val * vdd, tdel, trise, tfall);
    V(count[1]) <+ transition(count_1_val * vdd, tdel, trise, tfall);
    V(count[2]) <+ transition(count_2_val * vdd, tdel, trise, tfall);
    V(count[3]) <+ transition(count_3_val * vdd, tdel, trise, tfall);
  end

endmodule
