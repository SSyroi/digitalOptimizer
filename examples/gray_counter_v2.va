// =============================================================================
// Cadence Spectre Verilog-A Model for AMS Digital Block: gray_counter
// Generated by Simulation-Driven Truth Table Synthesizer
// =============================================================================
`include "constants.vams"
`include "disciplines.vams"

module gray_counter_va (clk, rst_n, ena, count_bin, count_gray);

  input clk;
  input rst_n;
  input ena;
  output [2:0] count_bin;
  output [2:0] count_gray;

  electrical clk;
  electrical rst_n;
  electrical ena;
  electrical [2:0] count_bin;
  electrical [2:0] count_gray;

  // ---------------------------------------------------------------------------
  // Technology & Timing Parameters (Cadence Spectre Compliant)
  // ---------------------------------------------------------------------------
  parameter real vdd   = 1.8;
  parameter real vth   = 0.9;
  parameter real tdel  = 10p; // Propagation delay
  parameter real trise = 10p; // Output rise time
  parameter real tfall = 10p; // Output fall time
  parameter real vtol  = 0;   // Voltage tolerance for cross event
  parameter real ttol  = 0;   // Time tolerance for cross event

  // ---------------------------------------------------------------------------
  // Custom Analog Standard Cell Gate Functions
  // ---------------------------------------------------------------------------
  analog function real INV;
    input a; real a;
    INV = (a > vth) ? 0.0 : 1.0;
  endfunction

  analog function real NAND2;
    input a, b; real a, b;
    NAND2 = !( (a > vth) && (b > vth) ) ? 1.0 : 0.0;
  endfunction

  analog function real NAND3;
    input a, b, c; real a, b, c;
    NAND3 = !( (a > vth) && (b > vth) && (c > vth) ) ? 1.0 : 0.0;
  endfunction

  analog function real NAND4;
    input a, b, c, d; real a, b, c, d;
    NAND4 = !( (a > vth) && (b > vth) && (c > vth) && (d > vth) ) ? 1.0 : 0.0;
  endfunction

  analog function real XOR2;
    input a, b; real a, b;
    XOR2 = ( (a > vth) ^ (b > vth) ) ? 1.0 : 0.0;
  endfunction

  // ---------------------------------------------------------------------------
  // Internal State & Combinational Variables
  // ---------------------------------------------------------------------------
  real q_0_q;
  real q_0_d;
  real q_1_q;
  real q_1_d;
  real q_2_q;
  real q_2_d;
  real count_bin_0_val;
  real count_bin_1_val;
  real count_bin_2_val;
  real count_gray_0_val;
  real count_gray_1_val;
  real count_gray_2_val;

  // ===========================================================================
  // Analog Behavioral Block
  // ===========================================================================
  analog begin
    // -------------------------------------------------------------------------
    // 1. Initial Step: DC Operating Point State Initialization
    // -------------------------------------------------------------------------
    @(initial_step("static", "ac")) begin
      q_0_q = 0.0;
      q_1_q = 0.0;
      q_2_q = 0.0;
    end

    // -------------------------------------------------------------------------
    // 2. Sequential Clock Cross Event (Register Updates)
    // -------------------------------------------------------------------------
    @(cross(V(clk) - vth, 1, vtol, ttol)) begin
      if (V(rst_n) < vth) begin
        q_0_q = 0.0;
        q_1_q = 0.0;
        q_2_q = 0.0;
      end else begin
        q_0_q = q_0_d;
        q_1_q = q_1_d;
        q_2_q = q_2_d;
      end
    end

    // -------------------------------------------------------------------------
    // 3. Combinational Logic Cones (Simplified & Tech-Mapped)
    // -------------------------------------------------------------------------
    // D-input for DFF q[0]:
    q_0_d = XOR2(V(ena), q_0_q);
    // D-input for DFF q[1]:
    q_1_d = NAND3(NAND3(V(ena), q_0_q, INV(q_1_q)), NAND2(INV(V(ena)), q_1_q), NAND2(INV(q_0_q), q_1_q));
    // D-input for DFF q[2]:
    q_2_d = NAND4(NAND4(V(ena), q_0_q, q_1_q, INV(q_2_q)), NAND2(INV(q_1_q), q_2_q), NAND2(INV(q_0_q), q_2_q), NAND2(INV(V(ena)), q_2_q));
    // Output count_bin[0]:
    count_bin_0_val = q_0_q;
    // Output count_bin[1]:
    count_bin_1_val = q_1_q;
    // Output count_bin[2]:
    count_bin_2_val = q_2_q;
    // Output count_gray[0]:
    count_gray_0_val = XOR2(q_0_q, q_1_q);
    // Output count_gray[1]:
    count_gray_1_val = XOR2(q_1_q, q_2_q);
    // Output count_gray[2]:
    count_gray_2_val = q_2_q;

    // -------------------------------------------------------------------------
    // 4. Analog Output Drivers (Continuous Transition Filters)
    // -------------------------------------------------------------------------
    V(count_bin[0]) <+ transition(count_bin_0_val * vdd, tdel, trise, tfall);
    V(count_bin[1]) <+ transition(count_bin_1_val * vdd, tdel, trise, tfall);
    V(count_bin[2]) <+ transition(count_bin_2_val * vdd, tdel, trise, tfall);
    V(count_gray[0]) <+ transition(count_gray_0_val * vdd, tdel, trise, tfall);
    V(count_gray[1]) <+ transition(count_gray_1_val * vdd, tdel, trise, tfall);
    V(count_gray[2]) <+ transition(count_gray_2_val * vdd, tdel, trise, tfall);
  end

endmodule
