`include "constants.vams"
`include "disciplines.vams"

// ============================================================================
// Module: sar_adc_ctrl_va
// Generated by AMS Digital Optimizer (Multi-Level DAG Synthesis Engine)
// Cadence Spectre & Virtuoso Compatible Verilog-A Model
//
// Circuit Complexity & Silicon Area Notes:
//   - Total Gate Count         : 59 cells
//   - Inverter Equivalents (GE) : 197.0 inverters (1 GE = 1 Inverter = 2 Transistors)
//   - Est. Transistor Count    : ~394 transistors
//
// Standard Cell Breakdown (Gate Counts & Inverter Weights):
//   - AND2    :   6 cells ( 18.0 inverters eq.,   36 transistors)
//   - AND3    :  10 cells ( 40.0 inverters eq.,   80 transistors)
//   - DFFR    :   8 cells ( 64.0 inverters eq.,  128 transistors)
//   - INV     :  15 cells ( 15.0 inverters eq.,   30 transistors)
//   - MUX2    :   5 cells ( 15.0 inverters eq.,   30 transistors)
//   - NOR2    :   3 cells (  6.0 inverters eq.,   12 transistors)
//   - OR2     :   9 cells ( 27.0 inverters eq.,   54 transistors)
//   - OR3     :   2 cells (  8.0 inverters eq.,   16 transistors)
//   - XOR2    :   1 cells (  4.0 inverters eq.,    8 transistors)
// ============================================================================

module sar_adc_ctrl_va (clk, rst_n, start, comp_out, dac_code, eoc, valid);
  input clk;
  electrical clk;
  input rst_n;
  electrical rst_n;
  input start;
  electrical start;
  input comp_out;
  electrical comp_out;
  output [3:0] dac_code;
  electrical [3:0] dac_code;
  output eoc;
  electrical eoc;
  output valid;
  electrical valid;

  // Electrical Parameters
  parameter real vhigh = 1.800;
  parameter real vlow  = 0.000;
  parameter real vth   = 0.900;
  parameter real tdel  = 30p;
  parameter real trise = 30p;
  parameter real tfall = 30p;

  // Analog Standard Cell Helper Functions
  analog function real INV;
    input a; real a;
    INV = !(a > vth) ? 1.0 : 0.0;
  endfunction

  analog function real NAND2;
    input a, b; real a, b;
    NAND2 = !((a > vth) && (b > vth)) ? 1.0 : 0.0;
  endfunction

  analog function real AND2;
    input a, b; real a, b;
    AND2 = ((a > vth) && (b > vth)) ? 1.0 : 0.0;
  endfunction

  analog function real NOR2;
    input a, b; real a, b;
    NOR2 = !((a > vth) || (b > vth)) ? 1.0 : 0.0;
  endfunction

  analog function real OR2;
    input a, b; real a, b;
    OR2 = ((a > vth) || (b > vth)) ? 1.0 : 0.0;
  endfunction

  analog function real XOR2;
    input a, b; real a, b;
    XOR2 = ((a > vth) != (b > vth)) ? 1.0 : 0.0;
  endfunction

  analog function real XNOR2;
    input a, b; real a, b;
    XNOR2 = ((a > vth) == (b > vth)) ? 1.0 : 0.0;
  endfunction

  analog function real MUX2;
    input s, d0, d1; real s, d0, d1;
    MUX2 = (s > vth) ? d1 : d0;
  endfunction

  analog function real AOI21;
    input a, b, c; real a, b, c;
    AOI21 = !(((a > vth) && (b > vth)) || (c > vth)) ? 1.0 : 0.0;
  endfunction

  analog function real OAI21;
    input a, b, c; real a, b, c;
    OAI21 = !(((a > vth) || (b > vth)) && (c > vth)) ? 1.0 : 0.0;
  endfunction

  analog function real NAND3;
    input a, b, c; real a, b, c;
    NAND3 = !((a > vth) && (b > vth) && (c > vth)) ? 1.0 : 0.0;
  endfunction

  analog function real AND3;
    input a, b, c; real a, b, c;
    AND3 = ((a > vth) && (b > vth) && (c > vth)) ? 1.0 : 0.0;
  endfunction

  analog function real NOR3;
    input a, b, c; real a, b, c;
    NOR3 = !((a > vth) || (b > vth) || (c > vth)) ? 1.0 : 0.0;
  endfunction

  analog function real OR3;
    input a, b, c; real a, b, c;
    OR3 = ((a > vth) || (b > vth) || (c > vth)) ? 1.0 : 0.0;
  endfunction

  analog function real NAND4;
    input a, b, c, d; real a, b, c, d;
    NAND4 = !((a > vth) && (b > vth) && (c > vth) && (d > vth)) ? 1.0 : 0.0;
  endfunction

  analog function real AND4;
    input a, b, c, d; real a, b, c, d;
    AND4 = ((a > vth) && (b > vth) && (c > vth) && (d > vth)) ? 1.0 : 0.0;
  endfunction

  // Internal State & Combinational Signals
  real dac_reg_3_q, dac_reg_3_d;
  real dac_reg_2_q, dac_reg_2_d;
  real dac_reg_1_q, dac_reg_1_d;
  real dac_reg_0_q, dac_reg_0_d;
  real state_2_q, state_2_d;
  real state_1_q, state_1_d;
  real state_0_q, state_0_d;
  real eoc_reg_q, eoc_reg_d;

  analog begin
    @(initial_step("static", "ac")) begin
      dac_reg_0_q = vlow;
      dac_reg_1_q = vlow;
      dac_reg_2_q = vlow;
      dac_reg_3_q = vlow;
      state_0_q = vlow;
      state_1_q = vlow;
      state_2_q = vlow;
      eoc_reg_q = vlow;
    end

    // Sequential Register Bank Clock Edge Sampling
    @(cross(V(clk) - vth, +1)) begin
      dac_reg_0_q = (dac_reg_0_d > vth) ? vhigh : vlow;
      dac_reg_1_q = (dac_reg_1_d > vth) ? vhigh : vlow;
      dac_reg_2_q = (dac_reg_2_d > vth) ? vhigh : vlow;
      dac_reg_3_q = (dac_reg_3_d > vth) ? vhigh : vlow;
      state_0_q = (state_0_d > vth) ? vhigh : vlow;
      state_1_q = (state_1_d > vth) ? vhigh : vlow;
      state_2_q = (state_2_d > vth) ? vhigh : vlow;
      eoc_reg_q = (eoc_reg_d > vth) ? vhigh : vlow;
    end

    // Multi-Level Combinational Logic Evaluations
    dac_reg_0_d = MUX2(dac_reg[0], MUX2(state[2], 0.0, NOR2(state[1], state[0])), OR3(state[2], state[1], state[0]));
    dac_reg_1_d = OR2(OR2(OR2(AND2(dac_reg[1], state[0]), AND3(INV(V(comp_out)), dac_reg[1], state[2])), AND2(dac_reg[1], state[1])), AND3(INV(state[2]), state[1], state[0]));
    dac_reg_2_d = OR2(OR2(OR2(AND3(dac_reg[2], INV(state[1]), state[0]), AND3(INV(state[2]), state[1], INV(state[0]))), AND2(dac_reg[2], state[2])), AND3(INV(V(comp_out)), dac_reg[2], state[0]));
    dac_reg_3_d = OR2(OR2(OR2(AND2(dac_reg[3], state[0]), AND3(INV(state[2]), INV(state[1]), state[0])), AND3(INV(V(comp_out)), dac_reg[3], state[1])), AND2(dac_reg[3], state[2]));
    state_0_d = OR3(AND3(state[2], INV(state[1]), INV(state[0])), AND3(INV(state[2]), state[1], INV(state[0])), AND3(V(start), INV(state[1]), INV(state[0])));
    state_1_d = MUX2(state[2], XOR2(state[1], state[0]), 0.0);
    state_2_d = MUX2(state[2], AND2(state[1], state[0]), NOR2(state[1], state[0]));
    eoc_reg_d = MUX2(state[2], 0.0, NOR2(state[1], state[0]));
    dac_code_0 = dac_reg[0];
    dac_code_1 = dac_reg[1];
    dac_code_2 = dac_reg[2];
    dac_code_3 = dac_reg[3];
    eoc = eoc_reg_q;
    valid = eoc_reg_q;

    // Analog Electrical Output Drivers
    V(dac_code[3]) <+ transition((dac_code_3 > vth) ? vhigh : vlow, tdel, trise, tfall);
    V(dac_code[2]) <+ transition((dac_code_2 > vth) ? vhigh : vlow, tdel, trise, tfall);
    V(dac_code[1]) <+ transition((dac_code_1 > vth) ? vhigh : vlow, tdel, trise, tfall);
    V(dac_code[0]) <+ transition((dac_code_0 > vth) ? vhigh : vlow, tdel, trise, tfall);
    V(eoc) <+ transition((eoc > vth) ? vhigh : vlow, tdel, trise, tfall);
    V(valid) <+ transition((valid > vth) ? vhigh : vlow, tdel, trise, tfall);
  end
endmodule
