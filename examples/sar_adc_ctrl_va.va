// =============================================================================
// Verilog-A Model for AMS Digital Block: sar_adc_ctrl
// Generated by AMS Digital Optimizer & Synthesizer
// =============================================================================
`include "disciplines.vams"
`include "constants.vams"

module sar_adc_ctrl_va (clk, rst_n, start, comp_out, dac_code, eoc, valid);

  input clk;
  input rst_n;
  input start;
  input comp_out;
  output [3:0] dac_code;
  output eoc;
  output valid;

  electrical clk;
  electrical rst_n;
  electrical start;
  electrical comp_out;
  electrical dac_code;
  electrical eoc;
  electrical valid;

  // ---------------------------------------------------------------------------
  // Technology & Timing Parameters
  // ---------------------------------------------------------------------------
  parameter real vdd = 1.8;
  parameter real vth = 0.9;
  parameter real tr  = 10p; // Output rise time
  parameter real tf  = 10p; // Output fall time

  // ---------------------------------------------------------------------------
  // Custom Analog Standard Cell Gate Functions
  // ---------------------------------------------------------------------------
  analog function real AND2;
    input a, b; real a, b;
    AND2 = ( (a > vth) && (b > vth) ) ? 1.0 : 0.0;
  endfunction

  analog function real AND3;
    input a, b, c; real a, b, c;
    AND3 = ( (a > vth) && (b > vth) && (c > vth) ) ? 1.0 : 0.0;
  endfunction

  analog function real INV;
    input a; real a;
    INV = (a > vth) ? 0.0 : 1.0;
  endfunction

  analog function real NAND2;
    input a, b; real a, b;
    NAND2 = !( (a > vth) && (b > vth) ) ? 1.0 : 0.0;
  endfunction

  analog function real NAND3;
    input a, b, c; real a, b, c;
    NAND3 = !( (a > vth) && (b > vth) && (c > vth) ) ? 1.0 : 0.0;
  endfunction

  analog function real OR2;
    input a, b; real a, b;
    OR2 = ( (a > vth) || (b > vth) ) ? 1.0 : 0.0;
  endfunction

  // ---------------------------------------------------------------------------
  // Internal State & Combinational Signals
  // ---------------------------------------------------------------------------
  real eoc_reg_q;
  real eoc_reg_d;
  real state_0_q;
  real state_0_d;
  real state_1_q;
  real state_1_d;
  real state_2_q;
  real state_2_d;
  real dac_reg_0_q;
  real dac_reg_0_d;
  real dac_reg_1_q;
  real dac_reg_1_d;
  real dac_reg_2_q;
  real dac_reg_2_d;
  real dac_reg_3_q;
  real dac_reg_3_d;
  real dac_code_0_val;
  real dac_code_1_val;
  real dac_code_2_val;
  real dac_code_3_val;
  real eoc_val;
  real valid_val;

  // ===========================================================================
  // SECTION 1: Sequential State Registers (Flip-Flops)
  // ===========================================================================
  @(cross(V(clk) - vth, +1)) begin
    if (V(rst_n) < vth) begin
      eoc_reg_q = 0.0;
      state_0_q = 0.0;
      state_1_q = 0.0;
      state_2_q = 0.0;
      dac_reg_0_q = 0.0;
      dac_reg_1_q = 0.0;
      dac_reg_2_q = 0.0;
      dac_reg_3_q = 0.0;
    end else begin
      eoc_reg_q = eoc_reg_d;
      state_0_q = state_0_d;
      state_1_q = state_1_d;
      state_2_q = state_2_d;
      dac_reg_0_q = dac_reg_0_d;
      dac_reg_1_q = dac_reg_1_d;
      dac_reg_2_q = dac_reg_2_d;
      dac_reg_3_q = dac_reg_3_d;
    end
  end

  // ===========================================================================
  // SECTION 2: Combinational Logic Cones (Simplified & Tech-Mapped)
  // ===========================================================================
  always @* begin
    // D-input for DFF eoc_reg:
    eoc_reg_d = NAND3(NAND2(eoc_reg_q, state_0_q), NAND2(eoc_reg_q, state_1_q), NAND3(state_2_q, INV(state_0_q), INV(state_1_q)));
    // D-input for DFF state[0]:
    state_0_d = NAND3(INV(state_0_q), NAND2(V(start), INV(state_2_q)), NAND2(state_1_q, INV(state_2_q)));
    // D-input for DFF state[1]:
    state_1_d = NAND3(INV(state_1_q), NAND2(V(start), INV(state_2_q)), NAND2(state_0_q, INV(state_2_q)));
    // D-input for DFF state[2]:
    state_2_d = NAND3(INV(state_0_q), INV(state_1_q), NAND2(V(start), INV(state_2_q)));
    // D-input for DFF dac_reg[0]:
    dac_reg_0_d = OR2(OR2(AND2(dac_reg_0_q, state_0_q), OR2(AND2(dac_reg_0_q, state_1_q), AND2(dac_reg_0_q, INV(state_2_q)))), OR2(AND3(state_0_q, state_1_q, INV(state_2_q)), OR2(AND2(AND2(V(comp_out), state_2_q), AND2(INV(state_0_q), INV(state_1_q))), AND2(AND2(V(start), INV(state_0_q)), AND2(INV(state_1_q), INV(state_2_q))))));
    // D-input for DFF dac_reg[1]:
    dac_reg_1_d = OR2(OR2(AND2(dac_reg_1_q, state_2_q), AND2(dac_reg_1_q, INV(state_1_q))), OR2(AND3(V(comp_out), state_1_q, INV(state_2_q)), OR2(AND3(V(start), INV(state_0_q), INV(state_2_q)), AND3(state_1_q, INV(state_0_q), INV(state_2_q)))));
    // D-input for DFF dac_reg[2]:
    dac_reg_2_d = OR2(OR2(AND2(dac_reg_2_q, state_0_q), OR2(AND2(dac_reg_2_q, state_2_q), AND2(dac_reg_2_q, INV(state_1_q)))), OR2(AND3(V(start), INV(state_1_q), INV(state_2_q)), OR2(AND3(state_0_q, INV(state_1_q), INV(state_2_q)), AND2(AND2(V(comp_out), state_1_q), AND2(INV(state_0_q), INV(state_2_q))))));
    // D-input for DFF dac_reg[3]:
    dac_reg_3_d = OR2(OR2(AND2(dac_reg_3_q, state_1_q), AND2(dac_reg_3_q, state_2_q)), OR2(AND2(dac_reg_3_q, INV(state_0_q)), OR2(AND2(AND2(V(comp_out), state_0_q), AND2(INV(state_1_q), INV(state_2_q))), AND2(AND2(V(start), INV(state_0_q)), AND2(INV(state_1_q), INV(state_2_q))))));
    // Output dac_code[0]:
    dac_code_0_val = dac_reg_0_q;
    // Output dac_code[1]:
    dac_code_1_val = dac_reg_1_q;
    // Output dac_code[2]:
    dac_code_2_val = dac_reg_2_q;
    // Output dac_code[3]:
    dac_code_3_val = dac_reg_3_q;
    // Output eoc:
    eoc_val = eoc_reg_q;
    // Output valid:
    valid_val = eoc_reg_q;
  end

  // ===========================================================================
  // SECTION 3: Analog Output Drivers
  // ===========================================================================
  V(dac_code[0]) <+ transition(dac_code_0_val * vdd, tr, tf);
  V(dac_code[1]) <+ transition(dac_code_1_val * vdd, tr, tf);
  V(dac_code[2]) <+ transition(dac_code_2_val * vdd, tr, tf);
  V(dac_code[3]) <+ transition(dac_code_3_val * vdd, tr, tf);
  V(eoc) <+ transition(eoc_val * vdd, tr, tf);
  V(valid) <+ transition(valid_val * vdd, tr, tf);

endmodule
