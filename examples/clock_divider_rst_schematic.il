;; ============================================================================
;; Cadence Virtuoso SKILL Schematic Generator: clock_divider_rst
;; Generated by AMS Digital Optimizer (Multi-Level DAG Engine)
;; ============================================================================

procedure( create_clock_divider_rst_schematic(libName cellName)
  let((cvId instId x y yStep)
    cvId = dbOpenCellViewByType(libName cellName "schematic" "schematic" "w")
    if( null(cvId) then
      error("Failed to open schematic cellview for write: %s/%s" libName cellName)
    )

    yStep = 1.5

    ;; --- Column 0: Sequential Register Bank (DFFR) ---
    x = 0.0
    y = 0.0
    instId = dbCreateInstByMasterName(cvId "tsmcN65" "DFFR" "symbol" "clk_out_dff" list(x y) "R0")
    y = y + yStep
    instId = dbCreateInstByMasterName(cvId "tsmcN65" "DFFR" "symbol" "cnt_reg_0_dff" list(x y) "R0")
    y = y + yStep
    instId = dbCreateInstByMasterName(cvId "tsmcN65" "DFFR" "symbol" "cnt_reg_1_dff" list(x y) "R0")
    y = y + yStep
    instId = dbCreateInstByMasterName(cvId "tsmcN65" "DFFR" "symbol" "cnt_reg_2_dff" list(x y) "R0")
    y = y + yStep
    instId = dbCreateInstByMasterName(cvId "tsmcN65" "DFFR" "symbol" "cnt_reg_3_dff" list(x y) "R0")
    y = y + yStep

    ;; --- Column 1: Multi-Level Combinational Gates ---
    x = 3.0
    y = 0.0
    ;; Node: clk_out = clk_out
    y = y + yStep
    ;; Node: clk_out_d = MUX2(clk_out, MUX2(load, MUX2(cnt_reg[3], NOR3(cnt_reg[2], cnt_reg[1], cnt_reg[0]), 0.0), 0.0), MUX2(load, MUX2(cnt_reg[3], OR3(cnt_reg[2], cnt_reg[1], cnt_reg[0]), 1.0), 0.0))
    y = y + yStep
    ;; Node: cnt_reg[0]_d = OR2(OR2(OR2(OR2(AND3(INV(load), cnt_reg[3], INV(cnt_reg[0])), AND2(load, div_ratio[0])), AND2(div_ratio[0], INV(cnt_reg[0]))), AND3(INV(load), cnt_reg[1], INV(cnt_reg[0]))), AND3(INV(load), cnt_reg[2], INV(cnt_reg[0])))
    y = y + yStep
    ;; Node: cnt_reg[1]_d = OR2(OR2(OR2(AND3(INV(load), cnt_reg[1], INV(cnt_reg[0])), AND3(INV(load), INV(cnt_reg[1]), cnt_reg[0])), AND2(load, div_ratio[1])), AND4(div_ratio[1], INV(cnt_reg[3]), INV(cnt_reg[2]), INV(cnt_reg[0])))
    y = y + yStep
    ;; Node: cnt_reg[2]_d = OR2(OR2(OR2(OR2(AND4(INV(load), INV(cnt_reg[2]), cnt_reg[1], cnt_reg[0]), AND3(INV(load), cnt_reg[2], INV(cnt_reg[1]))), AND2(load, div_ratio[2])), AND4(div_ratio[2], INV(cnt_reg[3]), INV(cnt_reg[1]), INV(cnt_reg[0]))), AND3(INV(load), cnt_reg[2], INV(cnt_reg[0])))
    y = y + yStep
    ;; Node: cnt_reg[3]_d = OR2(OR2(OR2(OR2(OR2(AND3(INV(load), cnt_reg[3], INV(cnt_reg[1])), AND3(INV(load), cnt_reg[3], INV(cnt_reg[2]))), AND4(div_ratio[3], INV(cnt_reg[2]), INV(cnt_reg[1]), INV(cnt_reg[0]))), AND3(INV(load), cnt_reg[3], INV(cnt_reg[0]))), AND2(AND2(AND2(AND2(INV(load), INV(cnt_reg[3])), cnt_reg[2]), cnt_reg[1]), cnt_reg[0])), AND2(load, div_ratio[3]))
    y = y + yStep
    ;; Node: count[0] = cnt_reg[0]
    y = y + yStep
    ;; Node: count[1] = cnt_reg[1]
    y = y + yStep
    ;; Node: count[2] = cnt_reg[2]
    y = y + yStep
    ;; Node: count[3] = cnt_reg[3]
    y = y + yStep

    ;; Save and Check
    schCheck(cvId)
    dbSave(cvId)
    dbClose(cvId)
    printf("[OK] Generated Virtuoso schematic for %s\n" cellName)
  )
)

;; Load and execute:
;; create_clock_divider_rst_schematic("my_ams_lib" "clock_divider_rst")
