;; ============================================================================
;; Cadence Virtuoso SKILL Schematic Generator: bandgap_trim_fsm
;; Generated by AMS Digital Optimizer (Multi-Level DAG Engine)
;; ============================================================================

procedure( create_bandgap_trim_fsm_schematic(libName cellName)
  let((cvId instId x y yStep)
    cvId = dbOpenCellViewByType(libName cellName "schematic" "schematic" "w")
    if( null(cvId) then
      error("Failed to open schematic cellview for write: %s/%s" libName cellName)
    )

    yStep = 1.5

    ;; --- Column 0: Sequential Register Bank (DFFR) ---
    x = 0.0
    y = 0.0
    instId = dbCreateInstByMasterName(cvId "tsmcN65" "DFFR" "symbol" "trim_reg_0_dff" list(x y) "R0")
    y = y + yStep
    instId = dbCreateInstByMasterName(cvId "tsmcN65" "DFFR" "symbol" "trim_reg_1_dff" list(x y) "R0")
    y = y + yStep
    instId = dbCreateInstByMasterName(cvId "tsmcN65" "DFFR" "symbol" "trim_reg_2_dff" list(x y) "R0")
    y = y + yStep
    instId = dbCreateInstByMasterName(cvId "tsmcN65" "DFFR" "symbol" "done_reg_dff" list(x y) "R0")
    y = y + yStep

    ;; --- Column 1: Multi-Level Combinational Gates ---
    x = 3.0
    y = 0.0
    ;; Node: trim_reg[0]_d = MUX2(trim_reg[0], MUX2(start_trim, 0.0, NOR2(comp_high, done_reg)), MUX2(start_trim, 1.0, OR2(comp_high, done_reg)))
    y = y + yStep
    ;; Node: trim_reg[1]_d = MUX2(trim_reg[1], MUX2(start_trim, 0.0, MUX2(comp_high, AND2(trim_reg[0], INV(done_reg)), 0.0)), MUX2(start_trim, 1.0, MUX2(comp_high, OR2(done_reg, INV(trim_reg[0])), 1.0)))
    y = y + yStep
    ;; Node: trim_reg[2]_d = MUX2(trim_reg[2], MUX2(start_trim, 0.0, MUX2(comp_high, MUX2(trim_reg[1], 0.0, AND2(trim_reg[0], INV(done_reg))), 0.0)), MUX2(start_trim, 1.0, MUX2(comp_high, MUX2(trim_reg[1], 1.0, OR2(done_reg, INV(trim_reg[0]))), 1.0)))
    y = y + yStep
    ;; Node: done_reg_d = MUX2(start_trim, done_reg, OR2(comp_high, done_reg))
    y = y + yStep
    ;; Node: trim_code[0] = trim_reg[0]
    y = y + yStep
    ;; Node: trim_code[1] = trim_reg[1]
    y = y + yStep
    ;; Node: trim_code[2] = trim_reg[2]
    y = y + yStep
    ;; Node: trim_done = done_reg
    y = y + yStep

    ;; Save and Check
    schCheck(cvId)
    dbSave(cvId)
    dbClose(cvId)
    printf("[OK] Generated Virtuoso schematic for %s\n" cellName)
  )
)

;; Load and execute:
;; create_bandgap_trim_fsm_schematic("my_ams_lib" "bandgap_trim_fsm")
