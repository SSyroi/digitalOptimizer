`include "constants.vams"
`include "disciplines.vams"

// ============================================================================
// Module: PWM_CTRL_va_fix
// Generated & Robustly Patched for Cadence Spectre & Virtuoso Compatibility
//
// Improvements & Fixes in this version (_fix):
//   1. Clean Input Variables: All digital inputs are sampled once cleanly at
//      the I/O boundary into meaningful 0.0/1.0 variables (c_DFT_en_PWM_in, etc.)
//      removing repetitive, messy inlined voltage comparisons from the logic.
//   2. Ground Referencing: All digital inputs and outputs are referenced
//      differentially to VSS (V(sig, VSS)), eliminating ground-offset errors
//      like the -8 mV level.
//   3. Dynamic Thresholding: Clock, reset, and logic thresholds dynamically
//      reference the actual supply rail 0.5 * V(VDD, VSS) with optional override.
//   4. LRM-Compliant Output Drivers: transition() filters operate on pure
//      discrete real values (0.0 / 1.0) and dynamically scale by V(VDD, VSS),
//      eliminating latched intermediate voltage artifacts (e.g. 269 mV).
//
// Circuit Complexity & Silicon Area Notes:
//   - Total Gate Count         : 77 cells
//   - Inverter Equivalents (GE) : 279.0 inverters (1 GE = 1 Inverter = 2 Transistors)
//   - Est. Transistor Count    : ~558 transistors
//
// Standard Cell Breakdown:
//   - AOI21   :   1 cells (  3.0 inverters eq.,    6 transistors)
//   - AOI22   :   6 cells ( 24.0 inverters eq.,   48 transistors)
//   - BUFFER  :   3 cells (  6.0 inverters eq.,   12 transistors)
//   - DFFR    :   6 cells (102.0 inverters eq.,  204 transistors)
//   - DFFS    :   1 cells ( 17.0 inverters eq.,   34 transistors)
//   - INV     :  28 cells ( 28.0 inverters eq.,   56 transistors)
//   - MUX2    :   7 cells ( 42.0 inverters eq.,   84 transistors)
//   - NAND2   :  14 cells ( 28.0 inverters eq.,   56 transistors)
//   - NAND3   :   4 cells ( 12.0 inverters eq.,   24 transistors)
//   - NAND4   :   1 cells (  4.0 inverters eq.,    8 transistors)
//   - NOR2    :   5 cells ( 10.0 inverters eq.,   20 transistors)
//   - NOR3    :   1 cells (  3.0 inverters eq.,    6 transistors)
// ============================================================================

module PWM_CTRL_va_fix (
  VDD, VSS, sub, res_n,
  c_DFT_en_LP, c_DFT_en_PWM, c_DfT_oc_dig_VDD,
  en_LP, oc_select, oc_ctrl_cp, oc_ctrl_bgr,
  clk_i, en_lowFreq,
  oc_select_ext, oc_ctrl_cp_ext, en_LP_ext,
  c_metalFix_invert_oc_defaults
);

  input VDD;
  electrical VDD;
  input VSS;
  electrical VSS;
  input sub;
  electrical sub;
  input res_n;
  electrical res_n;
  input c_DFT_en_LP;
  electrical c_DFT_en_LP;
  input c_DFT_en_PWM;
  electrical c_DFT_en_PWM;
  input [1:0] c_DfT_oc_dig_VDD;
  electrical [1:0] c_DfT_oc_dig_VDD;
  output en_LP;
  electrical en_LP;
  output oc_select;
  electrical oc_select;
  output oc_ctrl_cp;
  electrical oc_ctrl_cp;
  output oc_ctrl_bgr;
  electrical oc_ctrl_bgr;
  input clk_i;
  electrical clk_i;
  output en_lowFreq;
  electrical en_lowFreq;
  output oc_select_ext;
  electrical oc_select_ext;
  output oc_ctrl_cp_ext;
  electrical oc_ctrl_cp_ext;
  output en_LP_ext;
  electrical en_LP_ext;
  input c_metalFix_invert_oc_defaults;
  electrical c_metalFix_invert_oc_defaults;

  // Electrical Parameters
  // vth: Static threshold override. When 0.0 (default), dynamic midpoint 0.5*V(VDD,VSS) is used.
  parameter real vth   = 0.0;
  parameter real tdel  = 30p;
  parameter real trise = 30p;
  parameter real tfall = 30p;

  // Analog Standard Cell Helper Functions (Pure 0.0 / 1.0 Boolean Logic)
  analog function real INV;
    input a; real a;
    INV = !(a > 0.5) ? 1.0 : 0.0;
  endfunction

  analog function real NAND2;
    input a, b; real a, b;
    NAND2 = !((a > 0.5) && (b > 0.5)) ? 1.0 : 0.0;
  endfunction

  analog function real AND2;
    input a, b; real a, b;
    AND2 = ((a > 0.5) && (b > 0.5)) ? 1.0 : 0.0;
  endfunction

  analog function real NOR2;
    input a, b; real a, b;
    NOR2 = !((a > 0.5) || (b > 0.5)) ? 1.0 : 0.0;
  endfunction

  analog function real OR2;
    input a, b; real a, b;
    OR2 = ((a > 0.5) || (b > 0.5)) ? 1.0 : 0.0;
  endfunction

  analog function real XOR2;
    input a, b; real a, b;
    XOR2 = ((a > 0.5) != (b > 0.5)) ? 1.0 : 0.0;
  endfunction

  analog function real XNOR2;
    input a, b; real a, b;
    XNOR2 = ((a > 0.5) == (b > 0.5)) ? 1.0 : 0.0;
  endfunction

  analog function real MUX2;
    input s, d0, d1; real s, d0, d1;
    MUX2 = (s > 0.5) ? d1 : d0;
  endfunction

  analog function real AOI21;
    input a, b, c; real a, b, c;
    AOI21 = !(((a > 0.5) && (b > 0.5)) || (c > 0.5)) ? 1.0 : 0.0;
  endfunction

  analog function real OAI21;
    input a, b, c; real a, b, c;
    OAI21 = !(((a > 0.5) || (b > 0.5)) && (c > 0.5)) ? 1.0 : 0.0;
  endfunction

  analog function real NAND3;
    input a, b, c; real a, b, c;
    NAND3 = !((a > 0.5) && (b > 0.5) && (c > 0.5)) ? 1.0 : 0.0;
  endfunction

  analog function real AND3;
    input a, b, c; real a, b, c;
    AND3 = ((a > 0.5) && (b > 0.5) && (c > 0.5)) ? 1.0 : 0.0;
  endfunction

  analog function real NOR3;
    input a, b, c; real a, b, c;
    NOR3 = !((a > 0.5) || (b > 0.5) || (c > 0.5)) ? 1.0 : 0.0;
  endfunction

  analog function real OR3;
    input a, b, c; real a, b, c;
    OR3 = ((a > 0.5) || (b > 0.5) || (c > 0.5)) ? 1.0 : 0.0;
  endfunction

  analog function real NAND4;
    input a, b, c, d; real a, b, c, d;
    NAND4 = !((a > 0.5) && (b > 0.5) && (c > 0.5) && (d > 0.5)) ? 1.0 : 0.0;
  endfunction

  analog function real AND4;
    input a, b, c, d; real a, b, c, d;
    AND4 = ((a > 0.5) && (b > 0.5) && (c > 0.5) && (d > 0.5)) ? 1.0 : 0.0;
  endfunction

  analog function real NOR4;
    input a, b, c, d; real a, b, c, d;
    NOR4 = !((a > 0.5) || (b > 0.5) || (c > 0.5) || (d > 0.5)) ? 1.0 : 0.0;
  endfunction

  analog function real OR4;
    input a, b, c, d; real a, b, c, d;
    OR4 = ((a > 0.5) || (b > 0.5) || (c > 0.5) || (d > 0.5)) ? 1.0 : 0.0;
  endfunction

  analog function real AOI22;
    input a, b, c, d; real a, b, c, d;
    AOI22 = !(((a > 0.5) && (b > 0.5)) || ((c > 0.5) && (d > 0.5))) ? 1.0 : 0.0;
  endfunction

  analog function real OAI22;
    input a, b, c, d; real a, b, c, d;
    OAI22 = !(((a > 0.5) || (b > 0.5)) && ((c > 0.5) || (d > 0.5))) ? 1.0 : 0.0;
  endfunction

  // Dynamic Threshold & Boundary Input Logic Variables
  real v_th;
  real c_DFT_en_PWM_in;
  real c_DFT_en_LP_in;
  real c_DfT_oc_dig_VDD_0_in;
  real c_DfT_oc_dig_VDD_1_in;
  real c_metalFix_invert_oc_defaults_in;

  // Sequential State Registers (Q and D)
  real cnt_0_q, cnt_0_d;
  real cnt_1_q, cnt_1_d;
  real cnt_2_q, cnt_2_d;
  real cnt_3_q, cnt_3_d;
  real startup_q, startup_d;
  real chopping_clk_q, chopping_clk_d;
  real pwm_chop_q, pwm_chop_d;

  // Intermediate Mode & Window Flags
  real eff_oc_mode_0_val;
  real eff_oc_mode_1_val;
  real is_az_mode_val;
  real is_static_0_val;
  real is_static_1_val;
  real is_chop_mode_val;
  real is_pwm_active_window_val;
  real is_pwm_sample_window_val;

  // Output Combinational Logic Variables
  real en_LP_val, en_LP_ext_val;
  real oc_select_val, oc_select_ext_val;
  real oc_ctrl_cp_val, oc_ctrl_cp_ext_val;
  real oc_ctrl_bgr_val;
  real en_lowFreq_val;

  analog begin
    // -------------------------------------------------------------------------
    // 1. Initial Step Reset Initialization
    // -------------------------------------------------------------------------
    @(initial_step) begin
      cnt_0_q        = 0.0;
      cnt_1_q        = 0.0;
      cnt_2_q        = 0.0;
      cnt_3_q        = 0.0;
      startup_q      = 1.0;
      chopping_clk_q = 0.0;
      pwm_chop_q     = 0.0;
    end

    // -------------------------------------------------------------------------
    // 2. Dynamic Threshold Computation (Referenced to VSS)
    // -------------------------------------------------------------------------
    v_th = (vth > 0.0) ? vth : (0.5 * V(VDD, VSS));

    // -------------------------------------------------------------------------
    // 3. Clean Input Voltage-to-Logic Sampling at I/O Boundary
    // -------------------------------------------------------------------------
    c_DFT_en_PWM_in                  = (V(c_DFT_en_PWM, VSS) > v_th) ? 1.0 : 0.0;
    c_DFT_en_LP_in                   = (V(c_DFT_en_LP, VSS) > v_th) ? 1.0 : 0.0;
    c_DfT_oc_dig_VDD_0_in            = (V(c_DfT_oc_dig_VDD[0], VSS) > v_th) ? 1.0 : 0.0;
    c_DfT_oc_dig_VDD_1_in            = (V(c_DfT_oc_dig_VDD[1], VSS) > v_th) ? 1.0 : 0.0;
    c_metalFix_invert_oc_defaults_in = (V(c_metalFix_invert_oc_defaults, VSS) > v_th) ? 1.0 : 0.0;

    // -------------------------------------------------------------------------
    // 4. Asynchronous Reset Event: res_n falling edge (active low)
    // -------------------------------------------------------------------------
    @(cross(V(res_n, VSS) - v_th, -1)) begin
      cnt_0_q        = 0.0;
      cnt_1_q        = 0.0;
      cnt_2_q        = 0.0;
      cnt_3_q        = 0.0;
      startup_q      = 1.0;
      chopping_clk_q = 0.0;
      pwm_chop_q     = 0.0;
    end

    // -------------------------------------------------------------------------
    // 5. Sequential Register Bank Clock Edge Sampling
    // -------------------------------------------------------------------------
    @(cross(V(clk_i, VSS) - v_th, +1)) begin
      if (V(res_n, VSS) > v_th) begin
        cnt_0_q        = (cnt_0_d > 0.5) ? 1.0 : 0.0;
        cnt_1_q        = (cnt_1_d > 0.5) ? 1.0 : 0.0;
        cnt_2_q        = (cnt_2_d > 0.5) ? 1.0 : 0.0;
        cnt_3_q        = (cnt_3_d > 0.5) ? 1.0 : 0.0;
        startup_q      = (startup_d > 0.5) ? 1.0 : 0.0;
        chopping_clk_q = (chopping_clk_d > 0.5) ? 1.0 : 0.0;
        pwm_chop_q     = (pwm_chop_d > 0.5) ? 1.0 : 0.0;
      end
    end

    // -------------------------------------------------------------------------
    // 6. Multi-Level Combinational Logic Evaluations (Clean Discrete Domain)
    // -------------------------------------------------------------------------
    // Counter & Sequential Next-State Networks
    cnt_0_d = INV(cnt_0_q);
    cnt_1_d = AOI22(INV(cnt_0_q), INV(cnt_1_q), cnt_0_q, cnt_1_q);
    cnt_2_d = MUX2(cnt_2_q, INV(NAND2(cnt_0_q, cnt_1_q)), NAND2(cnt_0_q, cnt_1_q));
    cnt_3_d = MUX2(cnt_3_q, INV(NAND3(cnt_0_q, cnt_1_q, cnt_2_q)), NAND3(cnt_0_q, cnt_1_q, cnt_2_q));
    startup_d = INV(NAND2(startup_q, NAND2(cnt_0_q, NOR3(cnt_1_q, cnt_2_q, cnt_3_q))));
    chopping_clk_d = INV(chopping_clk_q);
    pwm_chop_d = MUX2(pwm_chop_q, NOR2(cnt_0_q, INV(NOR3(cnt_1_q, cnt_2_q, cnt_3_q))), NAND2(INV(cnt_0_q), NOR3(cnt_1_q, cnt_2_q, cnt_3_q)));

    // Mode Decoding Logic
    eff_oc_mode_0_val = AOI22(INV(c_DfT_oc_dig_VDD_0_in), INV(c_metalFix_invert_oc_defaults_in), c_DfT_oc_dig_VDD_0_in, c_metalFix_invert_oc_defaults_in);
    eff_oc_mode_1_val = AOI22(INV(c_DfT_oc_dig_VDD_1_in), INV(c_metalFix_invert_oc_defaults_in), c_DfT_oc_dig_VDD_1_in, c_metalFix_invert_oc_defaults_in);
    is_az_mode_val    = NOR2(eff_oc_mode_0_val, eff_oc_mode_1_val);
    is_static_0_val   = INV(NAND2(eff_oc_mode_0_val, INV(eff_oc_mode_1_val)));
    is_static_1_val   = eff_oc_mode_0_val;
    is_chop_mode_val  = INV(NAND2(eff_oc_mode_0_val, eff_oc_mode_1_val));

    // PWM Windows
    is_pwm_active_window_val = NOR3(cnt_1_q, cnt_2_q, cnt_3_q);
    is_pwm_sample_window_val = NOR2(cnt_0_q, INV(NOR3(cnt_1_q, cnt_2_q, cnt_3_q)));

    // Primary Control Outputs
    oc_select_val     = INV(AOI22(INV(c_DFT_en_LP_in), is_chop_mode_val, INV(c_DFT_en_LP_in), is_az_mode_val));
    oc_select_ext_val = oc_select_val;

    oc_ctrl_cp_val    = NOR2(c_DFT_en_LP_in, MUX2(c_DFT_en_PWM_in, NAND3(NAND4(INV(cnt_0_q), is_az_mode_val, INV(is_chop_mode_val), INV(startup_q)), NAND3(INV(is_az_mode_val), INV(is_chop_mode_val), INV(is_static_1_val)), NAND2(chopping_clk_q, is_chop_mode_val)), MUX2(is_az_mode_val, INV(AOI22(INV(is_chop_mode_val), INV(is_static_1_val), is_chop_mode_val, pwm_chop_q)), INV(is_pwm_sample_window_val))));
    oc_ctrl_cp_ext_val = oc_ctrl_cp_val;

    en_LP_val         = INV(AOI21(c_DFT_en_PWM_in, INV(is_pwm_active_window_val), c_DFT_en_LP_in));
    en_LP_ext_val     = en_LP_val;

    oc_ctrl_bgr_val   = NOR2(c_DFT_en_LP_in, MUX2(c_DFT_en_PWM_in, NAND3(NAND4(INV(cnt_0_q), is_az_mode_val, INV(is_chop_mode_val), INV(startup_q)), NAND2(INV(chopping_clk_q), is_chop_mode_val), NAND3(INV(is_az_mode_val), INV(is_chop_mode_val), INV(is_static_1_val))), MUX2(is_az_mode_val, INV(AOI22(INV(is_chop_mode_val), INV(is_static_1_val), is_chop_mode_val, INV(pwm_chop_q))), INV(is_pwm_sample_window_val))));

    en_lowFreq_val    = NOR2(c_DFT_en_LP_in, INV(NAND2(NAND2(c_DFT_en_PWM_in, INV(is_pwm_active_window_val)), NAND2(INV(NAND2(INV(NAND2(INV(NAND2(INV(c_DFT_en_PWM_in), INV(cnt_0_q))), is_az_mode_val)), INV(is_chop_mode_val))), INV(startup_q)))));

    // -------------------------------------------------------------------------
    // 7. Analog Electrical Output Drivers (Referenced to VSS, Scaled by V(VDD,VSS))
    // -------------------------------------------------------------------------
    V(en_LP, VSS)          <+ transition(en_LP_val, tdel, trise, tfall) * V(VDD, VSS);
    V(oc_select, VSS)      <+ transition(oc_select_val, tdel, trise, tfall) * V(VDD, VSS);
    V(oc_ctrl_cp, VSS)     <+ transition(oc_ctrl_cp_val, tdel, trise, tfall) * V(VDD, VSS);
    V(oc_ctrl_bgr, VSS)    <+ transition(oc_ctrl_bgr_val, tdel, trise, tfall) * V(VDD, VSS);
    V(en_lowFreq, VSS)     <+ transition(en_lowFreq_val, tdel, trise, tfall) * V(VDD, VSS);
    V(oc_select_ext, VSS)  <+ transition(oc_select_ext_val, tdel, trise, tfall) * V(VDD, VSS);
    V(oc_ctrl_cp_ext, VSS) <+ transition(oc_ctrl_cp_ext_val, tdel, trise, tfall) * V(VDD, VSS);
    V(en_LP_ext, VSS)      <+ transition(en_LP_ext_val, tdel, trise, tfall) * V(VDD, VSS);
  end

endmodule
