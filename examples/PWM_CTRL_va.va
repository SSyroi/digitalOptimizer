`include "constants.vams"
`include "disciplines.vams"

// ============================================================================
// Module: PWM_CTRL_va
// Generated by AMS Digital Optimizer (Multi-Level DAG Synthesis Engine)
// Cadence Spectre & Virtuoso Compatible Verilog-A Model
//
// Circuit Complexity & Silicon Area Notes:
//   - Total Gate Count         : 42 cells
//   - Inverter Equivalents (GE) : 128.0 inverters (1 GE = 1 Inverter = 2 Transistors)
//   - Est. Transistor Count    : ~256 transistors
//
// Standard Cell Breakdown (Gate Counts & Inverter Weights):
//   - AND2    :  12 cells ( 36.0 inverters eq.,   72 transistors)
//   - AND3    :   2 cells (  8.0 inverters eq.,   16 transistors)
//   - DFFR    :   4 cells ( 32.0 inverters eq.,   64 transistors)
//   - INV     :  11 cells ( 11.0 inverters eq.,   22 transistors)
//   - MUX2    :   4 cells ( 12.0 inverters eq.,   24 transistors)
//   - NOR2    :   1 cells (  2.0 inverters eq.,    4 transistors)
//   - OR2     :   5 cells ( 15.0 inverters eq.,   30 transistors)
//   - OR3     :   3 cells ( 12.0 inverters eq.,   24 transistors)
// ============================================================================

module PWM_CTRL_va (clk, rst_n, en_LP_ext, oc_select_ext, oc_ctrl_cp_ext, c_DfT_oc_dig_VDD, cnt, en_LP, en_LowFreq, oc_select, oc_ctrl_bgr, oc_ctrl_cp, is_az_mode, eff_oc_mode);
  input clk;
  electrical clk;
  input rst_n;
  electrical rst_n;
  input en_LP_ext;
  electrical en_LP_ext;
  input oc_select_ext;
  electrical oc_select_ext;
  input oc_ctrl_cp_ext;
  electrical oc_ctrl_cp_ext;
  input [1:0] c_DfT_oc_dig_VDD;
  electrical [1:0] c_DfT_oc_dig_VDD;
  output [3:0] cnt;
  electrical [3:0] cnt;
  output en_LP;
  electrical en_LP;
  output en_LowFreq;
  electrical en_LowFreq;
  output oc_select;
  electrical oc_select;
  output oc_ctrl_bgr;
  electrical oc_ctrl_bgr;
  output oc_ctrl_cp;
  electrical oc_ctrl_cp;
  output is_az_mode;
  electrical is_az_mode;
  output [1:0] eff_oc_mode;
  electrical [1:0] eff_oc_mode;

  // Electrical Parameters
  parameter real vhigh = 1.800;
  parameter real vlow  = 0.000;
  parameter real vth   = 0.900;
  parameter real tdel  = 30p;
  parameter real trise = 30p;
  parameter real tfall = 30p;

  // Analog Standard Cell Helper Functions
  analog function real INV;
    input a; real a;
    INV = !(a > vth) ? 1.0 : 0.0;
  endfunction

  analog function real NAND2;
    input a, b; real a, b;
    NAND2 = !((a > vth) && (b > vth)) ? 1.0 : 0.0;
  endfunction

  analog function real AND2;
    input a, b; real a, b;
    AND2 = ((a > vth) && (b > vth)) ? 1.0 : 0.0;
  endfunction

  analog function real NOR2;
    input a, b; real a, b;
    NOR2 = !((a > vth) || (b > vth)) ? 1.0 : 0.0;
  endfunction

  analog function real OR2;
    input a, b; real a, b;
    OR2 = ((a > vth) || (b > vth)) ? 1.0 : 0.0;
  endfunction

  analog function real XOR2;
    input a, b; real a, b;
    XOR2 = ((a > vth) != (b > vth)) ? 1.0 : 0.0;
  endfunction

  analog function real XNOR2;
    input a, b; real a, b;
    XNOR2 = ((a > vth) == (b > vth)) ? 1.0 : 0.0;
  endfunction

  analog function real MUX2;
    input s, d0, d1; real s, d0, d1;
    MUX2 = (s > vth) ? d1 : d0;
  endfunction

  analog function real AOI21;
    input a, b, c; real a, b, c;
    AOI21 = !(((a > vth) && (b > vth)) || (c > vth)) ? 1.0 : 0.0;
  endfunction

  analog function real OAI21;
    input a, b, c; real a, b, c;
    OAI21 = !(((a > vth) || (b > vth)) && (c > vth)) ? 1.0 : 0.0;
  endfunction

  analog function real NAND3;
    input a, b, c; real a, b, c;
    NAND3 = !((a > vth) && (b > vth) && (c > vth)) ? 1.0 : 0.0;
  endfunction

  analog function real AND3;
    input a, b, c; real a, b, c;
    AND3 = ((a > vth) && (b > vth) && (c > vth)) ? 1.0 : 0.0;
  endfunction

  analog function real NOR3;
    input a, b, c; real a, b, c;
    NOR3 = !((a > vth) || (b > vth) || (c > vth)) ? 1.0 : 0.0;
  endfunction

  analog function real OR3;
    input a, b, c; real a, b, c;
    OR3 = ((a > vth) || (b > vth) || (c > vth)) ? 1.0 : 0.0;
  endfunction

  analog function real NAND4;
    input a, b, c, d; real a, b, c, d;
    NAND4 = !((a > vth) && (b > vth) && (c > vth) && (d > vth)) ? 1.0 : 0.0;
  endfunction

  analog function real AND4;
    input a, b, c, d; real a, b, c, d;
    AND4 = ((a > vth) && (b > vth) && (c > vth) && (d > vth)) ? 1.0 : 0.0;
  endfunction

  // Internal State & Combinational Signals
  real cnt_3_q, cnt_3_d;
  real cnt_2_q, cnt_2_d;
  real cnt_1_q, cnt_1_d;
  real cnt_0_q, cnt_0_d;
  real eff_oc_mode_0;
  real eff_oc_mode_1;
  real is_az_mode;
  real is_chop_mode;
  real is_pwm_active_window;
  real is_pwm_sample_window;

  analog begin
    @(initial_step("static", "ac")) begin
      cnt_0_q = vlow;
      cnt_1_q = vlow;
      cnt_2_q = vlow;
      cnt_3_q = vlow;
    end

    // Sequential Register Bank Clock Edge Sampling
    @(cross(V(clk) - vth, +1)) begin
      cnt_0_q = (cnt_0_d > vth) ? vhigh : vlow;
      cnt_1_q = (cnt_1_d > vth) ? vhigh : vlow;
      cnt_2_q = (cnt_2_d > vth) ? vhigh : vlow;
      cnt_3_q = (cnt_3_d > vth) ? vhigh : vlow;
    end

    // Multi-Level Combinational Logic Evaluations
    eff_oc_mode_0 = c_DfT_oc_dig_VDD[0];
    eff_oc_mode_1 = c_DfT_oc_dig_VDD[1];
    is_az_mode = NOR2(eff_oc_mode[1], eff_oc_mode[0]);
    is_chop_mode = AND2(eff_oc_mode[1], INV(eff_oc_mode[0]));
    is_pwm_active_window = OR2(OR2(OR2(AND2(cnt[2], INV(cnt[3])), AND2(INV(cnt[2]), cnt[3])), AND2(cnt[1], INV(cnt[3]))), AND3(INV(cnt[0]), INV(cnt[1]), cnt[3]));
    is_pwm_sample_window = MUX2(cnt[0], AND3(cnt[1], cnt[2], cnt[3]), MUX2(cnt[1], AND2(cnt[2], cnt[3]), AND2(cnt[2], cnt[3])));
    cnt_3 = cnt[3];
    cnt_2 = cnt[2];
    cnt_1 = cnt[1];
    cnt_0 = cnt[0];
    cnt_0_d = cnt[0];
    cnt_1_d = cnt[1];
    cnt_2_d = cnt[2];
    cnt_3_d = cnt[3];
    en_LP = OR3(is_az_mode, AND2(is_chop_mode, is_pwm_active_window), AND2(INV(is_chop_mode), V(en_LP_ext)));
    en_LowFreq = MUX2(is_az_mode, OR2(INV(is_chop_mode), is_pwm_sample_window), 0.0);
    oc_select = OR3(is_az_mode, AND2(is_chop_mode, is_pwm_active_window), AND2(INV(is_chop_mode), V(oc_select_ext)));
    oc_ctrl_bgr = MUX2(is_az_mode, OR2(INV(is_chop_mode), is_pwm_sample_window), 0.0);
    oc_ctrl_cp = OR3(is_az_mode, AND2(is_chop_mode, is_pwm_active_window), AND2(INV(is_chop_mode), V(oc_ctrl_cp_ext)));

    // Analog Electrical Output Drivers
    V(cnt[3]) <+ transition((cnt_3_q > vth) ? vhigh : vlow, tdel, trise, tfall);
    V(cnt[2]) <+ transition((cnt_2_q > vth) ? vhigh : vlow, tdel, trise, tfall);
    V(cnt[1]) <+ transition((cnt_1_q > vth) ? vhigh : vlow, tdel, trise, tfall);
    V(cnt[0]) <+ transition((cnt_0_q > vth) ? vhigh : vlow, tdel, trise, tfall);
    V(en_LP) <+ transition((en_LP > vth) ? vhigh : vlow, tdel, trise, tfall);
    V(en_LowFreq) <+ transition((en_LowFreq > vth) ? vhigh : vlow, tdel, trise, tfall);
    V(oc_select) <+ transition((oc_select > vth) ? vhigh : vlow, tdel, trise, tfall);
    V(oc_ctrl_bgr) <+ transition((oc_ctrl_bgr > vth) ? vhigh : vlow, tdel, trise, tfall);
    V(oc_ctrl_cp) <+ transition((oc_ctrl_cp > vth) ? vhigh : vlow, tdel, trise, tfall);
    V(is_az_mode) <+ transition((is_az_mode > vth) ? vhigh : vlow, tdel, trise, tfall);
    V(eff_oc_mode[1]) <+ transition((eff_oc_mode_1 > vth) ? vhigh : vlow, tdel, trise, tfall);
    V(eff_oc_mode[0]) <+ transition((eff_oc_mode_0 > vth) ? vhigh : vlow, tdel, trise, tfall);
  end
endmodule
