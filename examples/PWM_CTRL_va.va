`include "constants.vams"
`include "disciplines.vams"

// ============================================================================
// Module: PWM_CTRL_va
// Generated by AMS Digital Optimizer (Multi-Level DAG Synthesis Engine)
// Cadence Spectre & Virtuoso Compatible Verilog-A Model
//
// Circuit Complexity & Silicon Area Notes:
//   - Total Gate Count         : 114 cells
//   - Inverter Equivalents (GE) : 507.0 inverters (1 GE = 1 Inverter = 2 Transistors)
//   - Est. Transistor Count    : ~1014 transistors
//
// Standard Cell Breakdown (Gate Counts & Inverter Weights):
//   - AND2    :  24 cells ( 72.0 inverters eq.,  144 transistors)
//   - AND3    :   2 cells (  8.0 inverters eq.,   16 transistors)
//   - AND4    :   8 cells ( 40.0 inverters eq.,   80 transistors)
//   - DFFR    :   7 cells (119.0 inverters eq.,  238 transistors)
//   - INV     :  13 cells ( 13.0 inverters eq.,   26 transistors)
//   - MUX2    :  22 cells (132.0 inverters eq.,  264 transistors)
//   - NAND2   :   3 cells (  6.0 inverters eq.,   12 transistors)
//   - NAND3   :   2 cells (  6.0 inverters eq.,   12 transistors)
//   - NOR2    :   1 cells (  2.0 inverters eq.,    4 transistors)
//   - NOR3    :   3 cells (  9.0 inverters eq.,   18 transistors)
//   - OR2     :  22 cells ( 66.0 inverters eq.,  132 transistors)
//   - OR3     :   4 cells ( 16.0 inverters eq.,   32 transistors)
//   - XOR2    :   3 cells ( 18.0 inverters eq.,   36 transistors)
// ============================================================================

module PWM_CTRL_va (VDD, VSS, sub, res_n, c_DFT_en_LP, c_DFT_en_PWM, c_DfT_oc_dig_VDD, en_LP, oc_select, oc_ctrl_cp, oc_ctrl_bgr, clk_i, en_lowFreq, oc_select_ext, oc_ctrl_cp_ext, en_LP_ext, c_metalFix_invert_oc_defaults);
  input VDD;
  electrical VDD;
  input VSS;
  electrical VSS;
  input sub;
  electrical sub;
  input res_n;
  electrical res_n;
  input c_DFT_en_LP;
  electrical c_DFT_en_LP;
  input c_DFT_en_PWM;
  electrical c_DFT_en_PWM;
  input [1:0] c_DfT_oc_dig_VDD;
  electrical [1:0] c_DfT_oc_dig_VDD;
  output en_LP;
  electrical en_LP;
  output oc_select;
  electrical oc_select;
  output oc_ctrl_cp;
  electrical oc_ctrl_cp;
  output oc_ctrl_bgr;
  electrical oc_ctrl_bgr;
  input clk_i;
  electrical clk_i;
  output en_lowFreq;
  electrical en_lowFreq;
  output oc_select_ext;
  electrical oc_select_ext;
  output oc_ctrl_cp_ext;
  electrical oc_ctrl_cp_ext;
  output en_LP_ext;
  electrical en_LP_ext;
  input c_metalFix_invert_oc_defaults;
  electrical c_metalFix_invert_oc_defaults;

  // Electrical Parameters
  parameter real vhigh = 1.800;
  parameter real vlow  = 0.000;
  parameter real vth   = 0.900;
  parameter real tdel  = 30p;
  parameter real trise = 30p;
  parameter real tfall = 30p;

  // Analog Standard Cell Helper Functions
  analog function real INV;
    input a; real a;
    INV = !(a > 0.900) ? 1.800 : 0.000;
  endfunction

  analog function real NAND2;
    input a, b; real a, b;
    NAND2 = !((a > 0.900) && (b > 0.900)) ? 1.800 : 0.000;
  endfunction

  analog function real AND2;
    input a, b; real a, b;
    AND2 = ((a > 0.900) && (b > 0.900)) ? 1.800 : 0.000;
  endfunction

  analog function real NOR2;
    input a, b; real a, b;
    NOR2 = !((a > 0.900) || (b > 0.900)) ? 1.800 : 0.000;
  endfunction

  analog function real OR2;
    input a, b; real a, b;
    OR2 = ((a > 0.900) || (b > 0.900)) ? 1.800 : 0.000;
  endfunction

  analog function real XOR2;
    input a, b; real a, b;
    XOR2 = ((a > 0.900) != (b > 0.900)) ? 1.800 : 0.000;
  endfunction

  analog function real XNOR2;
    input a, b; real a, b;
    XNOR2 = ((a > 0.900) == (b > 0.900)) ? 1.800 : 0.000;
  endfunction

  analog function real MUX2;
    input s, d0, d1; real s, d0, d1;
    MUX2 = (s > 0.900) ? d1 : d0;
  endfunction

  analog function real AOI21;
    input a, b, c; real a, b, c;
    AOI21 = !(((a > 0.900) && (b > 0.900)) || (c > 0.900)) ? 1.800 : 0.000;
  endfunction

  analog function real OAI21;
    input a, b, c; real a, b, c;
    OAI21 = !(((a > 0.900) || (b > 0.900)) && (c > 0.900)) ? 1.800 : 0.000;
  endfunction

  analog function real NAND3;
    input a, b, c; real a, b, c;
    NAND3 = !((a > 0.900) && (b > 0.900) && (c > 0.900)) ? 1.800 : 0.000;
  endfunction

  analog function real AND3;
    input a, b, c; real a, b, c;
    AND3 = ((a > 0.900) && (b > 0.900) && (c > 0.900)) ? 1.800 : 0.000;
  endfunction

  analog function real NOR3;
    input a, b, c; real a, b, c;
    NOR3 = !((a > 0.900) || (b > 0.900) || (c > 0.900)) ? 1.800 : 0.000;
  endfunction

  analog function real OR3;
    input a, b, c; real a, b, c;
    OR3 = ((a > 0.900) || (b > 0.900) || (c > 0.900)) ? 1.800 : 0.000;
  endfunction

  analog function real NAND4;
    input a, b, c, d; real a, b, c, d;
    NAND4 = !((a > 0.900) && (b > 0.900) && (c > 0.900) && (d > 0.900)) ? 1.800 : 0.000;
  endfunction

  analog function real AND4;
    input a, b, c, d; real a, b, c, d;
    AND4 = ((a > 0.900) && (b > 0.900) && (c > 0.900) && (d > 0.900)) ? 1.800 : 0.000;
  endfunction

  analog function real NOR4;
    input a, b, c, d; real a, b, c, d;
    NOR4 = !((a > 0.900) || (b > 0.900) || (c > 0.900) || (d > 0.900)) ? 1.800 : 0.000;
  endfunction

  analog function real OR4;
    input a, b, c, d; real a, b, c, d;
    OR4 = ((a > 0.900) || (b > 0.900) || (c > 0.900) || (d > 0.900)) ? 1.800 : 0.000;
  endfunction

  // Internal State & Combinational Signals
  real cnt_0_q, cnt_0_d;
  real cnt_1_q, cnt_1_d;
  real cnt_2_q, cnt_2_d;
  real cnt_3_q, cnt_3_d;
  real startup_q, startup_d;
  real chopping_clk_q, chopping_clk_d;
  real pwm_chop_q, pwm_chop_d;
  real eff_oc_mode_0_val;
  real eff_oc_mode_1_val;
  real is_az_mode_val;
  real is_static_0_val;
  real is_static_1_val;
  real is_chop_mode_val;
  real is_pwm_active_window_val;
  real is_pwm_sample_window_val;
  real oc_select_ext_val;
  real oc_ctrl_cp_ext_val;
  real en_LP_ext_val;
  real en_lowFreq_val;
  real oc_ctrl_cp_val;
  real oc_select_val;
  real oc_ctrl_bgr_val;
  real en_LP_val;

  analog begin
    @(initial_step) begin
      cnt_0_q = vlow;
      cnt_1_q = vlow;
      cnt_2_q = vlow;
      cnt_3_q = vlow;
      startup_q = vhigh;
      chopping_clk_q = vlow;
      pwm_chop_q = vlow;
    end

    // Asynchronous Reset Event: res_n falling edge (active low)
    @(cross(V(res_n) - vth, -1)) begin
      cnt_0_q = vlow;
      cnt_1_q = vlow;
      cnt_2_q = vlow;
      cnt_3_q = vlow;
      startup_q = vhigh;
      chopping_clk_q = vlow;
      pwm_chop_q = vlow;
    end

    // Sequential Register Bank Clock Edge Sampling
    @(cross(V(clk_i) - vth, +1)) begin
      if (V(res_n) > vth) begin
        cnt_0_q = (cnt_0_d > vth) ? vhigh : vlow;
        cnt_1_q = (cnt_1_d > vth) ? vhigh : vlow;
        cnt_2_q = (cnt_2_d > vth) ? vhigh : vlow;
        cnt_3_q = (cnt_3_d > vth) ? vhigh : vlow;
        startup_q = (startup_d > vth) ? vhigh : vlow;
        chopping_clk_q = (chopping_clk_d > vth) ? vhigh : vlow;
        pwm_chop_q = (pwm_chop_d > vth) ? vhigh : vlow;
      end
    end

    // Multi-Level Combinational Logic Evaluations
    cnt_0_d = INV(cnt_0_q);
    cnt_1_d = XOR2(cnt_0_q, cnt_1_q);
    cnt_2_d = MUX2(cnt_2_q, AND2(cnt_0_q, cnt_1_q), NAND2(cnt_0_q, cnt_1_q));
    cnt_3_d = MUX2(cnt_3_q, AND3(cnt_0_q, cnt_1_q, cnt_2_q), NAND3(cnt_0_q, cnt_1_q, cnt_2_q));
    startup_d = AND2(startup_q, OR2(INV(cnt_0_q), NAND3(cnt_1_q, cnt_2_q, cnt_3_q)));
    chopping_clk_d = INV(chopping_clk_q);
    pwm_chop_d = MUX2(pwm_chop_q, AND2(INV(cnt_0_q), NOR3(cnt_1_q, cnt_2_q, cnt_3_q)), OR2(cnt_0_q, OR3(cnt_1_q, cnt_2_q, cnt_3_q)));
    eff_oc_mode_0_val = XOR2(V(c_DfT_oc_dig_VDD[0]), V(c_metalFix_invert_oc_defaults));
    eff_oc_mode_1_val = XOR2(V(c_DfT_oc_dig_VDD[1]), V(c_metalFix_invert_oc_defaults));
    is_az_mode_val = NOR2(eff_oc_mode_0_val, eff_oc_mode_1_val);
    is_static_0_val = AND2(eff_oc_mode_0_val, INV(eff_oc_mode_1_val));
    is_static_1_val = AND2(INV(eff_oc_mode_0_val), eff_oc_mode_1_val);
    is_chop_mode_val = AND2(eff_oc_mode_0_val, eff_oc_mode_1_val);
    is_pwm_active_window_val = NOR3(cnt_1_q, cnt_2_q, cnt_3_q);
    is_pwm_sample_window_val = MUX2(cnt_0_q, NOR3(cnt_1_q, cnt_2_q, cnt_3_q), AND3(cnt_1_q, cnt_2_q, cnt_3_q));
    oc_select_val = AND2(INV(V(c_DFT_en_LP)), OR2(is_az_mode_val, is_chop_mode_val));
    oc_select_ext_val = oc_select_val;
    oc_ctrl_cp_val = AND2(INV(V(c_DFT_en_LP)), MUX2(V(c_DFT_en_PWM), MUX2(chopping_clk_q, OR2(is_chop_mode_val, MUX2(cnt_0_q, MUX2(is_static_1_val, AND2(INV(cnt_1_q), AND4(INV(cnt_2_q), INV(cnt_3_q), is_az_mode_val, startup_q)), OR2(INV(is_az_mode_val), AND4(INV(cnt_1_q), INV(cnt_2_q), INV(cnt_3_q), startup_q))), OR2(is_az_mode_val, is_static_1_val))), AND2(INV(is_chop_mode_val), MUX2(cnt_0_q, MUX2(is_static_1_val, AND2(INV(cnt_1_q), AND4(INV(cnt_2_q), INV(cnt_3_q), is_az_mode_val, startup_q)), OR2(INV(is_az_mode_val), AND4(INV(cnt_1_q), INV(cnt_2_q), INV(cnt_3_q), startup_q))), OR2(is_az_mode_val, is_static_1_val)))), MUX2(is_az_mode_val, OR2(AND2(is_chop_mode_val, INV(pwm_chop_q)), AND2(INV(is_chop_mode_val), is_static_1_val)), is_pwm_sample_window_val)));
    oc_ctrl_cp_ext_val = oc_ctrl_cp_val;
    en_LP_val = OR2(V(c_DFT_en_LP), AND2(V(c_DFT_en_PWM), INV(is_pwm_active_window_val)));
    en_LP_ext_val = en_LP_val;
    en_lowFreq_val = AND2(INV(V(c_DFT_en_LP)), MUX2(V(c_DFT_en_PWM), AND2(INV(cnt_0_q), AND2(is_az_mode_val, AND2(INV(is_chop_mode_val), OR2(cnt_1_q, OR3(cnt_2_q, cnt_3_q, INV(startup_q)))))), INV(is_pwm_active_window_val)));
    oc_ctrl_bgr_val = AND2(INV(V(c_DFT_en_LP)), MUX2(V(c_DFT_en_PWM), MUX2(chopping_clk_q, AND2(INV(is_chop_mode_val), MUX2(cnt_0_q, MUX2(is_static_1_val, AND2(INV(cnt_1_q), AND4(INV(cnt_2_q), INV(cnt_3_q), is_az_mode_val, startup_q)), OR2(INV(is_az_mode_val), AND4(INV(cnt_1_q), INV(cnt_2_q), INV(cnt_3_q), startup_q))), MUX2(is_static_1_val, AND2(is_az_mode_val, OR2(cnt_1_q, OR3(cnt_2_q, cnt_3_q, INV(startup_q)))), OR2(cnt_1_q, OR2(cnt_2_q, OR2(cnt_3_q, NAND2(is_az_mode_val, startup_q))))))), OR2(is_chop_mode_val, MUX2(cnt_0_q, MUX2(is_static_1_val, AND2(INV(cnt_1_q), AND4(INV(cnt_2_q), INV(cnt_3_q), is_az_mode_val, startup_q)), OR2(INV(is_az_mode_val), AND4(INV(cnt_1_q), INV(cnt_2_q), INV(cnt_3_q), startup_q))), MUX2(is_static_1_val, AND2(is_az_mode_val, OR2(cnt_1_q, OR3(cnt_2_q, cnt_3_q, INV(startup_q)))), OR2(cnt_1_q, OR2(cnt_2_q, OR2(cnt_3_q, NAND2(is_az_mode_val, startup_q)))))))), MUX2(is_az_mode_val, MUX2(is_chop_mode_val, is_static_1_val, pwm_chop_q), is_pwm_sample_window_val)));

    // Analog Electrical Output Drivers
    V(en_LP) <+ transition((en_LP_val > vth) ? vhigh : vlow, tdel, trise, tfall);
    V(oc_select) <+ transition((oc_select_val > vth) ? vhigh : vlow, tdel, trise, tfall);
    V(oc_ctrl_cp) <+ transition((oc_ctrl_cp_val > vth) ? vhigh : vlow, tdel, trise, tfall);
    V(oc_ctrl_bgr) <+ transition((oc_ctrl_bgr_val > vth) ? vhigh : vlow, tdel, trise, tfall);
    V(en_lowFreq) <+ transition((en_lowFreq_val > vth) ? vhigh : vlow, tdel, trise, tfall);
    V(oc_select_ext) <+ transition((oc_select_ext_val > vth) ? vhigh : vlow, tdel, trise, tfall);
    V(oc_ctrl_cp_ext) <+ transition((oc_ctrl_cp_ext_val > vth) ? vhigh : vlow, tdel, trise, tfall);
    V(en_LP_ext) <+ transition((en_LP_ext_val > vth) ? vhigh : vlow, tdel, trise, tfall);
  end
endmodule
