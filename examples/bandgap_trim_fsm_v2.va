// =============================================================================
// Cadence Spectre Verilog-A Model for AMS Digital Block: bandgap_trim_fsm
// Generated by Simulation-Driven Truth Table Synthesizer
// =============================================================================
`include "constants.vams"
`include "disciplines.vams"

module bandgap_trim_fsm_va (clk, rst_n, start_trim, comp_high, trim_code, trim_done);

  input clk;
  input rst_n;
  input start_trim;
  input comp_high;
  output [2:0] trim_code;
  output trim_done;

  electrical clk;
  electrical rst_n;
  electrical start_trim;
  electrical comp_high;
  electrical [2:0] trim_code;
  electrical trim_done;

  // ---------------------------------------------------------------------------
  // Technology & Timing Parameters (Cadence Spectre Compliant)
  // ---------------------------------------------------------------------------
  parameter real vdd   = 1.8;
  parameter real vth   = 0.9;
  parameter real tdel  = 10p; // Propagation delay
  parameter real trise = 10p; // Output rise time
  parameter real tfall = 10p; // Output fall time
  parameter real vtol  = 0;   // Voltage tolerance for cross event
  parameter real ttol  = 0;   // Time tolerance for cross event

  // ---------------------------------------------------------------------------
  // Custom Analog Standard Cell Gate Functions
  // ---------------------------------------------------------------------------
  analog function real AND2;
    input a, b; real a, b;
    AND2 = ( (a > vth) && (b > vth) ) ? 1.0 : 0.0;
  endfunction

  analog function real INV;
    input a; real a;
    INV = (a > vth) ? 0.0 : 1.0;
  endfunction

  analog function real NAND2;
    input a, b; real a, b;
    NAND2 = !( (a > vth) && (b > vth) ) ? 1.0 : 0.0;
  endfunction

  analog function real NAND3;
    input a, b, c; real a, b, c;
    NAND3 = !( (a > vth) && (b > vth) && (c > vth) ) ? 1.0 : 0.0;
  endfunction

  analog function real NAND4;
    input a, b, c, d; real a, b, c, d;
    NAND4 = !( (a > vth) && (b > vth) && (c > vth) && (d > vth) ) ? 1.0 : 0.0;
  endfunction

  // ---------------------------------------------------------------------------
  // Internal State & Combinational Variables
  // ---------------------------------------------------------------------------
  real done_reg_q;
  real done_reg_d;
  real trim_reg_0_q;
  real trim_reg_0_d;
  real trim_reg_1_q;
  real trim_reg_1_d;
  real trim_reg_2_q;
  real trim_reg_2_d;
  real trim_code_0_val;
  real trim_code_1_val;
  real trim_code_2_val;
  real trim_done_val;

  // ===========================================================================
  // Analog Behavioral Block
  // ===========================================================================
  analog begin
    // -------------------------------------------------------------------------
    // 1. Initial Step: DC Operating Point State Initialization
    // -------------------------------------------------------------------------
    @(initial_step("static", "ac")) begin
      done_reg_q = 0.0;
      trim_reg_0_q = 0.0;
      trim_reg_1_q = 0.0;
      trim_reg_2_q = 0.0;
    end

    // -------------------------------------------------------------------------
    // 2. Sequential Clock Cross Event (Register Updates)
    // -------------------------------------------------------------------------
    @(cross(V(clk) - vth, 1, vtol, ttol)) begin
      if (V(rst_n) < vth) begin
        done_reg_q = 0.0;
        trim_reg_0_q = 0.0;
        trim_reg_1_q = 0.0;
        trim_reg_2_q = 0.0;
      end else begin
        done_reg_q = done_reg_d;
        trim_reg_0_q = trim_reg_0_d;
        trim_reg_1_q = trim_reg_1_d;
        trim_reg_2_q = trim_reg_2_d;
      end
    end

    // -------------------------------------------------------------------------
    // 3. Combinational Logic Cones (Simplified & Tech-Mapped)
    // -------------------------------------------------------------------------
    // D-input for DFF done_reg:
    done_reg_d = NAND2(NAND2(V(start_trim), V(comp_high)), done_reg_q);
    // D-input for DFF trim_reg[0]:
    trim_reg_0_d = NAND4(NAND2(V(comp_high), trim_reg_0_q), NAND2(INV(V(start_trim)), trim_reg_0_q), NAND2(done_reg_q, trim_reg_0_q), NAND4(V(start_trim), INV(V(comp_high)), INV(done_reg_q), INV(trim_reg_0_q)));
    // D-input for DFF trim_reg[1]:
    trim_reg_1_d = NAND2(NAND2(NAND2(INV(trim_reg_0_q), trim_reg_1_q), NAND2(INV(V(start_trim)), trim_reg_1_q)), NAND3(NAND2(V(comp_high), trim_reg_1_q), AND2(AND2(V(start_trim), INV(V(comp_high))), AND2(INV(done_reg_q), AND2(trim_reg_0_q, INV(trim_reg_1_q)))), NAND2(done_reg_q, trim_reg_1_q)));
    // D-input for DFF trim_reg[2]:
    trim_reg_2_d = NAND2(NAND3(AND2(AND2(V(start_trim), AND2(INV(V(comp_high)), INV(done_reg_q))), AND2(trim_reg_0_q, AND2(trim_reg_1_q, INV(trim_reg_2_q)))), NAND2(done_reg_q, trim_reg_2_q), NAND2(INV(trim_reg_0_q), trim_reg_2_q)), NAND3(NAND2(INV(trim_reg_1_q), trim_reg_2_q), NAND2(INV(V(start_trim)), trim_reg_2_q), NAND2(V(comp_high), trim_reg_2_q)));
    // Output trim_code[0]:
    trim_code_0_val = trim_reg_0_q;
    // Output trim_code[1]:
    trim_code_1_val = trim_reg_1_q;
    // Output trim_code[2]:
    trim_code_2_val = trim_reg_2_q;
    // Output trim_done:
    trim_done_val = done_reg_q;

    // -------------------------------------------------------------------------
    // 4. Analog Output Drivers (Continuous Transition Filters)
    // -------------------------------------------------------------------------
    V(trim_code[0]) <+ transition(trim_code_0_val * vdd, tdel, trise, tfall);
    V(trim_code[1]) <+ transition(trim_code_1_val * vdd, tdel, trise, tfall);
    V(trim_code[2]) <+ transition(trim_code_2_val * vdd, tdel, trise, tfall);
    V(trim_done) <+ transition(trim_done_val * vdd, tdel, trise, tfall);
  end

endmodule
