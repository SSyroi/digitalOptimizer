`include "constants.vams"
`include "disciplines.vams"

// ============================================================================
// Module: gray_counter_va
// Generated by AMS Digital Optimizer (Multi-Level DAG Synthesis Engine)
// Cadence Spectre & Virtuoso Compatible Verilog-A Model
//
// Circuit Complexity & Silicon Area Notes:
//   - Total Gate Count         : 11 cells
//   - Inverter Equivalents (GE) : 53.0 inverters (1 GE = 1 Inverter = 2 Transistors)
//   - Est. Transistor Count    : ~106 transistors
//
// Standard Cell Breakdown (Gate Counts & Inverter Weights):
//   - AND3    :   1 cells (  4.0 inverters eq.,    8 transistors)
//   - DFFR    :   3 cells ( 24.0 inverters eq.,   48 transistors)
//   - MUX2    :   2 cells (  6.0 inverters eq.,   12 transistors)
//   - NAND3   :   1 cells (  3.0 inverters eq.,    6 transistors)
//   - XOR2    :   4 cells ( 16.0 inverters eq.,   32 transistors)
// ============================================================================

module gray_counter_va (clk, rst_n, ena, count_bin, count_gray);
  input clk;
  electrical clk;
  input rst_n;
  electrical rst_n;
  input ena;
  electrical ena;
  output [2:0] count_bin;
  electrical [2:0] count_bin;
  output [2:0] count_gray;
  electrical [2:0] count_gray;

  // Electrical Parameters
  parameter real vhigh = 1.800;
  parameter real vlow  = 0.000;
  parameter real vth   = 0.900;
  parameter real tdel  = 30p;
  parameter real trise = 30p;
  parameter real tfall = 30p;

  // Analog Standard Cell Helper Functions
  analog function real INV;
    input a; real a;
    INV = !(a > vth) ? 1.0 : 0.0;
  endfunction

  analog function real NAND2;
    input a, b; real a, b;
    NAND2 = !((a > vth) && (b > vth)) ? 1.0 : 0.0;
  endfunction

  analog function real AND2;
    input a, b; real a, b;
    AND2 = ((a > vth) && (b > vth)) ? 1.0 : 0.0;
  endfunction

  analog function real NOR2;
    input a, b; real a, b;
    NOR2 = !((a > vth) || (b > vth)) ? 1.0 : 0.0;
  endfunction

  analog function real OR2;
    input a, b; real a, b;
    OR2 = ((a > vth) || (b > vth)) ? 1.0 : 0.0;
  endfunction

  analog function real XOR2;
    input a, b; real a, b;
    XOR2 = ((a > vth) != (b > vth)) ? 1.0 : 0.0;
  endfunction

  analog function real XNOR2;
    input a, b; real a, b;
    XNOR2 = ((a > vth) == (b > vth)) ? 1.0 : 0.0;
  endfunction

  analog function real MUX2;
    input s, d0, d1; real s, d0, d1;
    MUX2 = (s > vth) ? d1 : d0;
  endfunction

  analog function real AOI21;
    input a, b, c; real a, b, c;
    AOI21 = !(((a > vth) && (b > vth)) || (c > vth)) ? 1.0 : 0.0;
  endfunction

  analog function real OAI21;
    input a, b, c; real a, b, c;
    OAI21 = !(((a > vth) || (b > vth)) && (c > vth)) ? 1.0 : 0.0;
  endfunction

  analog function real NAND3;
    input a, b, c; real a, b, c;
    NAND3 = !((a > vth) && (b > vth) && (c > vth)) ? 1.0 : 0.0;
  endfunction

  analog function real AND3;
    input a, b, c; real a, b, c;
    AND3 = ((a > vth) && (b > vth) && (c > vth)) ? 1.0 : 0.0;
  endfunction

  analog function real NOR3;
    input a, b, c; real a, b, c;
    NOR3 = !((a > vth) || (b > vth) || (c > vth)) ? 1.0 : 0.0;
  endfunction

  analog function real OR3;
    input a, b, c; real a, b, c;
    OR3 = ((a > vth) || (b > vth) || (c > vth)) ? 1.0 : 0.0;
  endfunction

  analog function real NAND4;
    input a, b, c, d; real a, b, c, d;
    NAND4 = !((a > vth) && (b > vth) && (c > vth) && (d > vth)) ? 1.0 : 0.0;
  endfunction

  analog function real AND4;
    input a, b, c, d; real a, b, c, d;
    AND4 = ((a > vth) && (b > vth) && (c > vth) && (d > vth)) ? 1.0 : 0.0;
  endfunction

  // Internal State & Combinational Signals
  real q_0_q, q_0_d;
  real q_1_q, q_1_d;
  real q_2_q, q_2_d;
  real count_bin_0_val;
  real count_bin_1_val;
  real count_bin_2_val;
  real count_gray_2_val;
  real count_gray_1_val;
  real count_gray_0_val;

  analog begin
    @(initial_step("static", "ac")) begin
      q_0_q = vlow;
      q_1_q = vlow;
      q_2_q = vlow;
    end

    // Sequential Register Bank Clock Edge Sampling
    @(cross(V(clk) - vth, +1)) begin
      q_0_q = (q_0_d > vth) ? vhigh : vlow;
      q_1_q = (q_1_d > vth) ? vhigh : vlow;
      q_2_q = (q_2_d > vth) ? vhigh : vlow;
    end

    // Multi-Level Combinational Logic Evaluations
    q_0_d = XOR2(q_0_q, V(ena));
    q_1_d = MUX2(q_0_q, q_1_q, XOR2(q_1_q, V(ena)));
    q_2_d = MUX2(q_2_q, AND3(q_0_q, q_1_q, V(ena)), NAND3(q_0_q, q_1_q, V(ena)));
    count_bin_0_val = q_0_q;
    count_bin_1_val = q_1_q;
    count_bin_2_val = q_2_q;
    count_gray_2_val = q_2_q;
    count_gray_1_val = XOR2(q_2_q, q_1_q);
    count_gray_0_val = XOR2(q_1_q, q_0_q);

    // Analog Electrical Output Drivers
    V(count_bin[2]) <+ transition((count_bin_2_val > vth) ? vhigh : vlow, tdel, trise, tfall);
    V(count_bin[1]) <+ transition((count_bin_1_val > vth) ? vhigh : vlow, tdel, trise, tfall);
    V(count_bin[0]) <+ transition((count_bin_0_val > vth) ? vhigh : vlow, tdel, trise, tfall);
    V(count_gray[2]) <+ transition((count_gray_2_val > vth) ? vhigh : vlow, tdel, trise, tfall);
    V(count_gray[1]) <+ transition((count_gray_1_val > vth) ? vhigh : vlow, tdel, trise, tfall);
    V(count_gray[0]) <+ transition((count_gray_0_val > vth) ? vhigh : vlow, tdel, trise, tfall);
  end
endmodule
